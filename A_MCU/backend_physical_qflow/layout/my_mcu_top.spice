* NGSPICE file created from my_mcu_top.ext - technology: scmos

* Black-box entry subcircuit for MUX2X1 abstract view
.subckt MUX2X1 A B S Y vdd gnd
.ends

* Black-box entry subcircuit for OAI21X1 abstract view
.subckt OAI21X1 A B C Y vdd gnd
.ends

* Black-box entry subcircuit for DFFPOSX1 abstract view
.subckt DFFPOSX1 D CLK Q vdd gnd
.ends

* Black-box entry subcircuit for FILL abstract view
.subckt FILL vdd gnd
.ends

* Black-box entry subcircuit for NAND2X1 abstract view
.subckt NAND2X1 A B Y vdd gnd
.ends

* Black-box entry subcircuit for NOR2X1 abstract view
.subckt NOR2X1 A B Y vdd gnd
.ends

* Black-box entry subcircuit for INVX1 abstract view
.subckt INVX1 A Y vdd gnd
.ends

* Black-box entry subcircuit for BUFX2 abstract view
.subckt BUFX2 A Y vdd gnd
.ends

* Black-box entry subcircuit for AOI21X1 abstract view
.subckt AOI21X1 A B C Y vdd gnd
.ends

* Black-box entry subcircuit for AND2X2 abstract view
.subckt AND2X2 A B Y vdd gnd
.ends

* Black-box entry subcircuit for NAND3X1 abstract view
.subckt NAND3X1 A B C Y vdd gnd
.ends

* Black-box entry subcircuit for CLKBUF1 abstract view
.subckt CLKBUF1 A Y vdd gnd
.ends

* Black-box entry subcircuit for OR2X2 abstract view
.subckt OR2X2 A B Y vdd gnd
.ends

* Black-box entry subcircuit for DFFSR abstract view
.subckt DFFSR R S D CLK Q vdd gnd
.ends

* Black-box entry subcircuit for INVX2 abstract view
.subckt INVX2 A Y vdd gnd
.ends

* Black-box entry subcircuit for OAI22X1 abstract view
.subckt OAI22X1 A B C D Y vdd gnd
.ends

* Black-box entry subcircuit for AOI22X1 abstract view
.subckt AOI22X1 A B C D Y vdd gnd
.ends

* Black-box entry subcircuit for INVX8 abstract view
.subckt INVX8 A Y vdd gnd
.ends

* Black-box entry subcircuit for INVX4 abstract view
.subckt INVX4 A Y vdd gnd
.ends

* Black-box entry subcircuit for NOR3X1 abstract view
.subckt NOR3X1 A B C Y vdd gnd
.ends

.subckt my_mcu_top gnd vdd i_clk_fast i_clk_sys_ext i_rst_n o_rf_sync o_rf_sck o_rf_mosi
+ i_rf_miso o_mem_sync o_mem_sck o_mem_mosi i_mem_miso
X_2106_ _4054_/Q _3916_/Q _2122_/S _2107_/B vdd gnd MUX2X1
X_2037_ _3638_/B _2045_/B _2037_/C _2038_/A vdd gnd OAI21X1
X_3086_ _3761_/Q _3086_/B _3671_/Y _3087_/B vdd gnd MUX2X1
X_3155_ _3715_/Q _3185_/B _3155_/C _3687_/A vdd gnd OAI21X1
X_3988_ _3988_/D _4009_/CLK _3988_/Q vdd gnd DFFPOSX1
X_2939_ _2939_/A _2939_/B _2939_/C _2940_/A vdd gnd OAI21X1
XFILL128850x25350 vdd gnd FILL
XFILL128850x115350 vdd gnd FILL
XFILL_0__2593_ vdd gnd FILL
XFILL_0__2662_ vdd gnd FILL
X_3842_ _3842_/D _3996_/CLK _3842_/Q vdd gnd DFFPOSX1
X_3911_ _3911_/D _3979_/CLK _3911_/Q vdd gnd DFFPOSX1
X_2724_ _3953_/Q _2784_/B _2725_/C vdd gnd NAND2X1
X_2655_ _2655_/A _2691_/A _2658_/B vdd gnd NOR2X1
X_3773_ _3773_/D _2373_/A _3773_/Q vdd gnd DFFPOSX1
XFILL_0__3076_ vdd gnd FILL
XFILL_0__2027_ vdd gnd FILL
X_2586_ _2943_/C _2946_/C vdd gnd INVX1
X_3207_ _3716_/Q _3213_/B _3213_/C _3208_/D vdd gnd OAI21X1
X_3069_ _3069_/A _3069_/B _3914_/R _3070_/A vdd gnd OAI21X1
X_3138_ _3138_/A _3295_/A _3211_/C _3742_/D vdd gnd OAI21X1
XBUFX2_insert100 _2577_/Y _3262_/B vdd gnd BUFX2
XBUFX2_insert111 _1908_/Y _2169_/A vdd gnd BUFX2
XBUFX2_insert177 _2817_/Y _2908_/A vdd gnd BUFX2
X_2440_ _2440_/A _2457_/A vdd gnd INVX1
XBUFX2_insert166 _1943_/Y _2133_/B vdd gnd BUFX2
X_2371_ _2505_/A _2371_/B _2371_/C _4027_/D vdd gnd AOI21X1
X_4041_ _4041_/D _4041_/CLK _4041_/Q vdd gnd DFFPOSX1
X_3756_ _3756_/D _4053_/CLK _3756_/Q vdd gnd DFFPOSX1
X_3825_ _3825_/D _4008_/CLK _3825_/Q vdd gnd DFFPOSX1
X_2707_ _3959_/Q _3957_/Q _2767_/S _2709_/B vdd gnd MUX2X1
X_2569_ _4009_/Q _3015_/B _2966_/B vdd gnd NAND2X1
X_2638_ _3992_/Q _2811_/B _2638_/C _2639_/C vdd gnd OAI21X1
X_3687_ _3687_/A _3697_/A vdd gnd INVX1
XFILL_0__2361_ vdd gnd FILL
XFILL_0__2292_ vdd gnd FILL
X_1871_ _3727_/Q _1876_/B _1871_/C _1872_/B vdd gnd AOI21X1
X_1940_ _4097_/Q _1940_/B _3084_/S _1941_/B vdd gnd MUX2X1
X_3610_ _3800_/Q _3613_/C vdd gnd INVX1
X_2423_ _3756_/Q _3096_/A vdd gnd INVX1
X_3472_ _3488_/A _3638_/B _3473_/C vdd gnd NAND2X1
X_3541_ _3541_/A _3541_/B _3545_/S _3924_/D vdd gnd MUX2X1
X_2354_ _3999_/Q _3824_/Q _2356_/B vdd gnd NAND2X1
X_4024_ _4024_/D _4035_/CLK _4024_/Q vdd gnd DFFPOSX1
X_2285_ _3443_/A _2285_/B _2285_/C _3414_/A vdd gnd AOI21X1
XBUFX2_insert0 _3404_/Y _3522_/S vdd gnd BUFX2
X_3739_ _3739_/D _4080_/CLK _3739_/Q vdd gnd DFFPOSX1
X_3808_ _3808_/D _3737_/D _3808_/Q vdd gnd DFFPOSX1
XFILL_0__1861_ vdd gnd FILL
XFILL_0__3600_ vdd gnd FILL
X_2070_ _2070_/A _3910_/R _4065_/D vdd gnd AND2X2
X_2972_ _3824_/Q _3014_/B _3902_/R _2973_/C vdd gnd OAI21X1
X_1923_ _3717_/Q _1938_/B _3082_/S _1924_/C vdd gnd NAND3X1
X_2406_ _2416_/C _2406_/B _3808_/Q _2408_/B vdd gnd OAI21X1
X_3386_ _3991_/Q _3387_/A _3394_/B vdd gnd NAND2X1
X_3455_ _3964_/Q _3458_/A vdd gnd INVX1
X_3524_ _3540_/A _3651_/B _3525_/C vdd gnd NAND2X1
X_2337_ _3999_/Q _3842_/Q _2337_/C _2517_/A vdd gnd OAI21X1
X_4007_ _4007_/D _4009_/CLK _4007_/Q vdd gnd DFFPOSX1
X_2268_ _3853_/A _3302_/B _2395_/B vdd gnd NOR2X1
X_2199_ _4032_/Q _3666_/Y _2200_/C vdd gnd NOR2X1
XFILL128550x126150 vdd gnd FILL
XFILL_0__2060_ vdd gnd FILL
XCLKBUF1_insert136 CLKBUF1_insert182/Y _3821_/CLK vdd gnd CLKBUF1
XCLKBUF1_insert158 CLKBUF1_insert184/Y _3980_/CLK vdd gnd CLKBUF1
X_3240_ _3774_/Q _3630_/A vdd gnd INVX1
XCLKBUF1_insert125 CLKBUF1_insert183/Y _3997_/CLK vdd gnd CLKBUF1
XCLKBUF1_insert147 CLKBUF1_insert184/Y _4092_/CLK vdd gnd CLKBUF1
X_2053_ _3636_/B _2053_/B _2053_/C _2054_/A vdd gnd OAI21X1
X_2122_ _4058_/Q _3830_/Q _2122_/S _2123_/B vdd gnd MUX2X1
XFILL_0__3514_ vdd gnd FILL
X_3171_ _4095_/Q _3694_/A _3171_/C _3695_/C vdd gnd OAI21X1
X_2955_ _3799_/Q _3014_/B _2956_/A vdd gnd NAND2X1
XCLKBUF1_insert51 i_clk_fast _2373_/A vdd gnd CLKBUF1
XFILL_0__3445_ vdd gnd FILL
X_2886_ _3871_/Q _3869_/Q _2890_/S _2888_/B vdd gnd MUX2X1
X_1906_ _3765_/Q _3180_/B _1906_/C _2192_/C vdd gnd OAI21X1
X_3507_ _3521_/A _3647_/B _3508_/C vdd gnd NAND2X1
X_3438_ _3970_/Q _3445_/A vdd gnd INVX1
X_3369_ _3369_/A _3371_/A _3372_/A _4002_/D vdd gnd MUX2X1
X_2740_ _3945_/Q _2741_/A _2741_/C vdd gnd NAND2X1
X_2671_ _3073_/A _2671_/B _3978_/D vdd gnd NOR2X1
XFILL_0__2945_ vdd gnd FILL
X_3223_ _4096_/Q _3308_/B _3224_/C vdd gnd NOR2X1
XFILL_0__2876_ vdd gnd FILL
XFILL_0__3428_ vdd gnd FILL
X_2105_ _2129_/A _2105_/B _2108_/A vdd gnd NOR2X1
X_2036_ _2036_/A _2036_/B _2133_/B _2037_/C vdd gnd OAI21X1
X_3154_ _3185_/B _3653_/A _3155_/C vdd gnd NAND2X1
X_3085_ _3707_/A _3085_/B _3763_/D vdd gnd NOR2X1
X_2938_ _3848_/Q _2939_/A _2939_/C vdd gnd NAND2X1
XFILL_0__3359_ vdd gnd FILL
X_3987_ _3987_/D _4049_/CLK _3987_/Q vdd gnd DFFPOSX1
X_2869_ _2869_/A _3165_/C _3883_/D vdd gnd AND2X2
XFILL_0__2730_ vdd gnd FILL
X_2723_ _3951_/Q _3949_/Q _2751_/S _2725_/B vdd gnd MUX2X1
XFILL_0__3213_ vdd gnd FILL
X_3841_ _3841_/A _3845_/Y _3841_/Y vdd gnd OR2X2
X_3910_ _3910_/R vdd _3910_/D _4090_/CLK _3910_/Q vdd gnd DFFSR
X_3772_ _3910_/R vdd _3772_/D _4090_/CLK _3772_/Q vdd gnd DFFSR
XFILL_0__3144_ vdd gnd FILL
X_2654_ _3971_/Q _2688_/B _2691_/A vdd gnd NAND2X1
X_2585_ _3902_/R _3706_/B _2943_/C vdd gnd NAND2X1
X_3206_ _3714_/Q _3208_/A vdd gnd INVX1
XFILL_0__2859_ vdd gnd FILL
X_3137_ _3691_/B _3698_/B _3211_/C vdd gnd NAND2X1
X_3068_ _3068_/A _3073_/C _3775_/D vdd gnd NOR2X1
X_2019_ _2131_/A _2019_/B _2020_/B vdd gnd NOR2X1
XBUFX2_insert101 _2577_/Y _3295_/A vdd gnd BUFX2
XBUFX2_insert112 _1908_/Y _3083_/A vdd gnd BUFX2
XBUFX2_insert167 _1943_/Y _2193_/B vdd gnd BUFX2
XBUFX2_insert178 _2817_/Y _2864_/A vdd gnd BUFX2
XFILL_0__2713_ vdd gnd FILL
X_2370_ _3914_/R _4027_/Q _2371_/C vdd gnd NAND2X1
XFILL_0__2644_ vdd gnd FILL
X_4040_ _4040_/D _4093_/CLK _4040_/Q vdd gnd DFFPOSX1
XFILL_0__3693_ vdd gnd FILL
XFILL_0__2575_ vdd gnd FILL
X_2706_ _2706_/A _2952_/C _3963_/D vdd gnd AND2X2
X_3824_ _3824_/D _3996_/CLK _3824_/Q vdd gnd DFFPOSX1
XFILL_0__3058_ vdd gnd FILL
X_3686_ _3686_/A _3686_/B _3822_/D vdd gnd AND2X2
X_3755_ _3755_/D _4053_/CLK _3755_/Q vdd gnd DFFPOSX1
XFILL_0__3127_ vdd gnd FILL
X_2637_ _2637_/A _2811_/B vdd gnd INVX2
X_2568_ _2568_/A _2966_/A vdd gnd INVX1
X_2499_ _3773_/Q _2500_/A vdd gnd INVX1
XFILL_0__2009_ vdd gnd FILL
X_1870_ _3727_/Q _1876_/B _3671_/Y _1871_/C vdd gnd OAI21X1
X_3540_ _3540_/A _3926_/Q _3540_/C _3541_/B vdd gnd OAI21X1
X_2353_ _2528_/A _2528_/B _2353_/C _2357_/A vdd gnd OAI21X1
X_2422_ _2441_/A _2441_/B _3383_/A vdd gnd NOR2X1
XFILL_0__3814_ vdd gnd FILL
X_3471_ _3956_/Q _3474_/A vdd gnd INVX1
X_4023_ _4023_/D _2373_/A _4023_/Q vdd gnd DFFPOSX1
XBUFX2_insert1 _3404_/Y _3545_/S vdd gnd BUFX2
X_2284_ _3413_/B _3412_/B _2284_/C _2285_/C vdd gnd AOI21X1
XFILL_0__2558_ vdd gnd FILL
XFILL_0__2489_ vdd gnd FILL
X_3807_ _3807_/D _4025_/CLK _3807_/Q vdd gnd DFFPOSX1
X_3738_ _3738_/D _4080_/CLK _3738_/Q vdd gnd DFFPOSX1
X_3669_ _3707_/A _3670_/Y _3669_/Y vdd gnd NOR2X1
X_1999_ _4081_/Q _3642_/B vdd gnd INVX1
XFILL_0__3461_ vdd gnd FILL
XFILL_0__2343_ vdd gnd FILL
X_2971_ _3815_/Q _3807_/Q _3805_/Q _2973_/B vdd gnd MUX2X1
XFILL_0__2274_ vdd gnd FILL
X_1922_ _4000_/Q _3816_/Q _2146_/S _1924_/B vdd gnd MUX2X1
XFILL_0__3392_ vdd gnd FILL
XFILL_0__2412_ vdd gnd FILL
X_3523_ _3930_/Q _3526_/A vdd gnd INVX1
X_2336_ _2529_/A _3836_/Q _2337_/C vdd gnd OR2X2
X_2405_ _3178_/A _2405_/B _2405_/C _2406_/B vdd gnd OAI21X1
X_3385_ _3853_/A _3739_/Q _3385_/C _3387_/A vdd gnd AOI21X1
X_3454_ _3454_/A _3454_/B _3549_/S _3966_/D vdd gnd MUX2X1
XFILL_0__1989_ vdd gnd FILL
X_2267_ _3277_/B _3275_/A _3270_/A _2271_/B vdd gnd NAND3X1
X_4006_ _4006_/D _4041_/CLK _4006_/Q vdd gnd DFFPOSX1
X_2198_ _2198_/A _2198_/B _2198_/C _2549_/B vdd gnd OAI21X1
XCLKBUF1_insert115 CLKBUF1_insert181/Y _3959_/CLK vdd gnd CLKBUF1
XCLKBUF1_insert137 CLKBUF1_insert181/Y _3979_/CLK vdd gnd CLKBUF1
XFILL_0__2892_ vdd gnd FILL
XFILL_0__2961_ vdd gnd FILL
XCLKBUF1_insert126 CLKBUF1_insert180/Y _4076_/CLK vdd gnd CLKBUF1
XCLKBUF1_insert148 CLKBUF1_insert185/Y _4058_/CLK vdd gnd CLKBUF1
X_3170_ _3694_/A _3649_/A _3171_/C vdd gnd NAND2X1
X_2052_ _2052_/A _2052_/B _2053_/B _2053_/C vdd gnd OAI21X1
X_2121_ _2129_/A _2121_/B _2124_/A vdd gnd NOR2X1
X_2954_ _4014_/Q _3015_/B _3836_/Q _2956_/B vdd gnd OAI21X1
XCLKBUF1_insert52 i_clk_fast _3837_/CLK vdd gnd CLKBUF1
X_2885_ _2885_/A _2917_/B _3875_/D vdd gnd AND2X2
XFILL_0__2257_ vdd gnd FILL
X_1905_ _2146_/S _1906_/C vdd gnd INVX1
XFILL_0__2188_ vdd gnd FILL
X_3506_ _3938_/Q _3509_/A vdd gnd INVX1
X_2319_ _2529_/A _3834_/Q _2320_/C vdd gnd OR2X2
X_3299_ _3849_/A _3739_/Q _3381_/A _3303_/B vdd gnd OAI21X1
X_3437_ _3442_/A _3445_/B _3437_/C _3437_/D _3972_/D vdd gnd OAI22X1
X_3368_ _4002_/Q _3371_/A vdd gnd INVX1
XFILL_0__3091_ vdd gnd FILL
XFILL_0__2111_ vdd gnd FILL
XFILL_0__3160_ vdd gnd FILL
X_2670_ _2670_/A _2813_/S _2670_/C _3979_/D vdd gnd AOI21X1
XFILL_0__2042_ vdd gnd FILL
X_3222_ _3276_/A _3222_/B _3222_/C _3224_/B vdd gnd OAI21X1
X_2104_ _4057_/Q _3962_/Q _2128_/S _2105_/B vdd gnd MUX2X1
X_3153_ _3882_/Q _3653_/A vdd gnd INVX1
X_2035_ _2131_/A _2035_/B _2036_/B vdd gnd NOR2X1
X_3084_ _3763_/Q _3084_/B _3084_/S _3085_/B vdd gnd MUX2X1
X_3986_ _3986_/D _3986_/CLK _3986_/Q vdd gnd DFFPOSX1
X_2937_ _3998_/Q _3994_/Q _2937_/S _2939_/B vdd gnd MUX2X1
X_2868_ _2880_/A _2868_/B _2868_/C _2869_/A vdd gnd OAI21X1
X_2799_ _3913_/Q _3911_/Q _2826_/S _2801_/B vdd gnd MUX2X1
XFILL128550x75750 vdd gnd FILL
XFILL_0__2660_ vdd gnd FILL
XFILL_0__2591_ vdd gnd FILL
X_3840_ _3840_/D _3840_/CLK _3840_/Q vdd gnd DFFPOSX1
X_2722_ _2722_/A _2782_/B _3955_/D vdd gnd AND2X2
X_3771_ _3771_/D _2373_/A _3771_/Q vdd gnd DFFPOSX1
X_2653_ _2683_/A _2683_/B _2688_/B vdd gnd NOR2X1
X_2584_ _4007_/Q _2587_/B vdd gnd INVX1
XFILL_0__2927_ vdd gnd FILL
X_3067_ _3914_/R _3067_/B _3068_/A vdd gnd NAND2X1
X_3205_ _3205_/A _3293_/B _3205_/C _3205_/D _3716_/D vdd gnd AOI22X1
XFILL129150x150 vdd gnd FILL
X_3136_ _3643_/A _3643_/B _3185_/B _3691_/B vdd gnd MUX2X1
X_2018_ _4031_/Q _3872_/Q _2122_/S _2019_/B vdd gnd MUX2X1
X_3969_ _3969_/D _3986_/CLK _3969_/Q vdd gnd DFFPOSX1
XBUFX2_insert179 _2817_/Y _2926_/B vdd gnd BUFX2
XBUFX2_insert102 _2577_/Y _3698_/B vdd gnd BUFX2
XBUFX2_insert113 _1908_/Y _2129_/A vdd gnd BUFX2
XBUFX2_insert168 _1943_/Y _2161_/B vdd gnd BUFX2
X_3823_ _3823_/D _3737_/D _3823_/Q vdd gnd DFFPOSX1
X_2705_ _2815_/A _2705_/B _2705_/C _2706_/A vdd gnd OAI21X1
X_2636_ _2639_/A _2931_/B _2636_/C _3994_/D vdd gnd AOI21X1
X_3685_ _3685_/A _3711_/A _3686_/A vdd gnd NAND2X1
X_3754_ _3754_/D _4053_/CLK _3754_/Q vdd gnd DFFPOSX1
X_2567_ _3988_/Q _4007_/Q _2568_/A vdd gnd NOR2X1
X_2498_ _2662_/A _2498_/B _2498_/C _2511_/B vdd gnd AOI21X1
X_3119_ _3295_/A _3120_/A _3121_/B vdd gnd OR2X2
X_4099_ _4099_/D _4099_/CLK _4099_/Q vdd gnd DFFPOSX1
XFILL_0__2290_ vdd gnd FILL
X_2352_ _3281_/C _2352_/B _2352_/C _2528_/B vdd gnd AOI21X1
X_2421_ _3301_/B _4070_/Q _3090_/A _2441_/A vdd gnd AOI21X1
X_3470_ _3470_/A _3470_/B _3470_/S _3958_/D vdd gnd MUX2X1
X_2283_ _3987_/Q _2284_/C vdd gnd INVX1
XFILL_0__2626_ vdd gnd FILL
XFILL_0__3675_ vdd gnd FILL
XBUFX2_insert2 _3404_/Y _3531_/S vdd gnd BUFX2
X_4022_ _4022_/D _4049_/CLK _4022_/Q vdd gnd DFFPOSX1
X_3806_ _3902_/R vdd _3806_/D _4084_/CLK _3806_/Q vdd gnd DFFSR
X_2619_ _3998_/Q _2934_/B _2934_/C vdd gnd NAND2X1
XFILL_0__3109_ vdd gnd FILL
X_3599_ _3601_/C _3613_/B _3599_/C _3613_/D _3831_/D vdd gnd OAI22X1
X_3668_ _3669_/Y _3668_/Y vdd gnd INVX1
X_1998_ _1998_/A _2189_/C _4083_/D vdd gnd AND2X2
X_3737_ _3737_/D _4016_/CLK _3737_/Q vdd gnd DFFPOSX1
X_2970_ _3014_/B _2970_/B _2970_/C _3826_/D vdd gnd AOI21X1
X_1921_ _2195_/C _1921_/B _3717_/D vdd gnd NOR2X1
X_3453_ _3548_/A _3920_/Q _3453_/C _3454_/B vdd gnd OAI21X1
X_3522_ _3522_/A _3522_/B _3522_/S _3932_/D vdd gnd MUX2X1
X_2335_ _3795_/Q _2342_/A _2335_/C _2347_/A vdd gnd AOI21X1
X_2266_ _4078_/Q _3270_/A vdd gnd INVX1
X_3384_ _3853_/Y _3738_/Q _3384_/C _3385_/C vdd gnd OAI21X1
X_2404_ _3738_/Q _3739_/Q _3215_/B _2405_/C vdd gnd AOI21X1
X_4005_ _4005_/D _4009_/CLK _4005_/Q vdd gnd DFFPOSX1
XFILL_0__2609_ vdd gnd FILL
XFILL_0__3589_ vdd gnd FILL
XFILL_0__3658_ vdd gnd FILL
X_2197_ _3158_/A _4016_/Q _2198_/B vdd gnd OR2X2
XFILL129150x57750 vdd gnd FILL
XCLKBUF1_insert149 CLKBUF1_insert181/Y _3893_/CLK vdd gnd CLKBUF1
XCLKBUF1_insert127 CLKBUF1_insert182/Y _4100_/CLK vdd gnd CLKBUF1
X_2120_ _4052_/Q _3966_/Q _2128_/S _2121_/B vdd gnd MUX2X1
XCLKBUF1_insert116 CLKBUF1_insert185/Y _4049_/CLK vdd gnd CLKBUF1
XFILL_0__1911_ vdd gnd FILL
XCLKBUF1_insert138 CLKBUF1_insert183/Y _3737_/D vdd gnd CLKBUF1
XFILL_0__3443_ vdd gnd FILL
X_2051_ _2177_/C _2051_/B _2052_/B vdd gnd NOR2X1
XFILL_0__3512_ vdd gnd FILL
XFILL_0__3374_ vdd gnd FILL
X_2953_ _3023_/C _3014_/B _2953_/C _3838_/D vdd gnd AOI21X1
XFILL_0__2325_ vdd gnd FILL
X_2884_ _2896_/A _2884_/B _2884_/C _2885_/A vdd gnd OAI21X1
X_1904_ _3845_/Y _3841_/A _1904_/C _1904_/Y vdd gnd OAI21X1
XCLKBUF1_insert53 i_clk_fast _4016_/CLK vdd gnd CLKBUF1
X_3436_ _3551_/A _4055_/Q _3445_/B _3437_/D vdd gnd OAI21X1
X_3505_ _3505_/A _3505_/B _3522_/S _3940_/D vdd gnd MUX2X1
X_2318_ _3999_/Q _3824_/Q _2590_/A _2355_/A _2606_/A vdd gnd AOI22X1
X_3298_ _3302_/B _3298_/B _3381_/A vdd gnd NAND2X1
X_3367_ _3367_/A _3369_/A _3372_/A _4004_/D vdd gnd MUX2X1
XFILL129150x32550 vdd gnd FILL
X_2249_ _3412_/B _2249_/B _2286_/C vdd gnd NAND2X1
XFILL_0__2943_ vdd gnd FILL
XFILL_0__2874_ vdd gnd FILL
X_3221_ _3221_/A _3305_/B _3308_/A _3222_/C vdd gnd OAI21X1
X_3152_ _3305_/A _3305_/B _3738_/Q _3216_/B vdd gnd OAI21X1
X_2103_ _4055_/Q _3629_/B vdd gnd INVX1
X_3083_ _3083_/A _3083_/B _3083_/C _3084_/B vdd gnd OAI21X1
XFILL_0__2308_ vdd gnd FILL
X_2034_ _4035_/Q _3880_/Q _2122_/S _2035_/B vdd gnd MUX2X1
XFILL_0__3357_ vdd gnd FILL
X_3985_ _3985_/D _3985_/CLK _3985_/Q vdd gnd DFFPOSX1
X_2798_ _2798_/A _2913_/B _3917_/D vdd gnd AND2X2
X_2936_ _2936_/A _2939_/A _2936_/C _3850_/D vdd gnd AOI21X1
XFILL_0__3288_ vdd gnd FILL
X_2867_ _3883_/Q _2880_/A _2868_/C vdd gnd NAND2X1
XFILL_0__2239_ vdd gnd FILL
X_3419_ _3429_/A _3428_/A _3420_/B vdd gnd NOR2X1
XFILL_0__3211_ vdd gnd FILL
X_2652_ _3975_/Q _2683_/B vdd gnd INVX1
X_2721_ _2784_/B _2721_/B _2721_/C _2722_/A vdd gnd OAI21X1
XFILL_0__3073_ vdd gnd FILL
X_3770_ _3914_/R vdd _3770_/D _4092_/CLK _3770_/Q vdd gnd DFFSR
XFILL_0__3142_ vdd gnd FILL
XFILL_0__2024_ vdd gnd FILL
X_2583_ _3281_/C _2583_/B _3025_/A _4009_/D vdd gnd AOI21X1
X_3204_ _3718_/Q _3213_/B _3289_/C _3205_/D vdd gnd OAI21X1
X_3066_ _3066_/A _3066_/B _3066_/C _3073_/C vdd gnd AOI21X1
XFILL_0__2788_ vdd gnd FILL
X_2017_ _2049_/A _2017_/B _2020_/A vdd gnd NOR2X1
X_3135_ _3734_/Q _3643_/A vdd gnd INVX1
X_2919_ _3856_/Q _2926_/B _2920_/C vdd gnd NAND2X1
X_3968_ _3968_/D _3985_/CLK _3968_/Q vdd gnd DFFPOSX1
X_3899_ _3899_/D _3907_/CLK _3899_/Q vdd gnd DFFPOSX1
XBUFX2_insert103 _2577_/Y _3290_/B vdd gnd BUFX2
XBUFX2_insert169 _1943_/Y _2125_/B vdd gnd BUFX2
XBUFX2_insert114 _1908_/Y _2081_/A vdd gnd BUFX2
XFILL_0__2573_ vdd gnd FILL
XFILL_0__3691_ vdd gnd FILL
XFILL_0__2642_ vdd gnd FILL
X_3822_ _3822_/D _3837_/CLK _3822_/Q vdd gnd DFFPOSX1
X_2704_ _3963_/Q _2815_/A _2705_/C vdd gnd NAND2X1
XFILL_0__3056_ vdd gnd FILL
X_2635_ _3994_/Q _2931_/B _2638_/C _2636_/C vdd gnd OAI21X1
X_3684_ _3684_/A _3684_/B _3711_/A vdd gnd NOR2X1
X_3753_ _3753_/D _3885_/CLK _3866_/B vdd gnd DFFPOSX1
XFILL_0__2007_ vdd gnd FILL
X_2566_ _3032_/B _3032_/A _4014_/Q _2571_/B vdd gnd AOI21X1
X_2497_ _2671_/B _2498_/B _3067_/B _2498_/C vdd gnd OAI21X1
X_3049_ _3049_/A _3049_/B _3073_/A _3787_/D vdd gnd AOI21X1
X_4098_ _4098_/D _4098_/CLK _4098_/Q vdd gnd DFFPOSX1
X_3118_ _3118_/A _3118_/B _3118_/C _3750_/D vdd gnd AOI21X1
X_2420_ _3732_/Q _3247_/A _3301_/B vdd gnd NAND2X1
X_4021_ _4021_/D _4021_/CLK _4021_/Q vdd gnd DFFPOSX1
X_2351_ _2351_/A _2352_/C vdd gnd INVX1
X_2282_ _3413_/B _3412_/B _3443_/A vdd gnd AND2X2
XFILL_0__2487_ vdd gnd FILL
XBUFX2_insert3 _3404_/Y _3470_/S vdd gnd BUFX2
X_3805_ _3805_/D _4014_/CLK _3805_/Q vdd gnd DFFPOSX1
X_1997_ _3643_/B _2045_/B _1997_/C _1998_/A vdd gnd OAI21X1
X_3736_ _3910_/R vdd _3736_/D _3964_/CLK _3736_/Q vdd gnd DFFSR
X_2618_ _3805_/Q _2618_/B _2632_/A vdd gnd NAND2X1
X_3598_ _3831_/Q _3601_/C vdd gnd INVX1
X_2549_ _3666_/Y _2549_/B _2550_/B vdd gnd NAND2X1
X_3667_ _3707_/Y _3699_/Y _3701_/Y _3667_/Y vdd gnd AOI21X1
XFILL_0__2341_ vdd gnd FILL
XFILL_0__3390_ vdd gnd FILL
XFILL_0__2272_ vdd gnd FILL
X_1920_ _3717_/Q _1920_/B _3084_/S _1921_/B vdd gnd MUX2X1
X_3383_ _3383_/A _3383_/B _3390_/A vdd gnd NAND2X1
X_2403_ _3853_/A _3741_/Q _3215_/B vdd gnd NOR2X1
X_3452_ _3488_/A _3633_/B _3453_/C vdd gnd NAND2X1
X_3521_ _3521_/A _3934_/Q _3521_/C _3522_/B vdd gnd OAI21X1
X_2334_ _3777_/Q _2529_/A _2334_/C _2335_/C vdd gnd OAI21X1
X_2265_ _4076_/Q _3275_/A vdd gnd INVX1
XFILL_0__1987_ vdd gnd FILL
X_4004_ _4004_/D _4041_/CLK _4004_/Q vdd gnd DFFPOSX1
X_2196_ _2196_/A _2196_/B _3158_/A vdd gnd NAND2X1
X_3719_ _3719_/D _4099_/CLK _3719_/Q vdd gnd DFFPOSX1
XCLKBUF1_insert117 CLKBUF1_insert182/Y _4009_/CLK vdd gnd CLKBUF1
XFILL_0__2890_ vdd gnd FILL
X_2050_ _4039_/Q _3888_/Q _2090_/S _2051_/B vdd gnd MUX2X1
XCLKBUF1_insert139 CLKBUF1_insert185/Y _4035_/CLK vdd gnd CLKBUF1
XCLKBUF1_insert128 CLKBUF1_insert184/Y _3940_/CLK vdd gnd CLKBUF1
X_2952_ _3838_/Q _3014_/B _2952_/C _2953_/C vdd gnd OAI21X1
X_2883_ _3875_/Q _2896_/A _2884_/C vdd gnd NAND2X1
XCLKBUF1_insert54 i_clk_fast _3162_/A vdd gnd CLKBUF1
X_1903_ _3118_/C _3810_/Y _1904_/C vdd gnd NOR2X1
XFILL_0__2186_ vdd gnd FILL
X_3435_ _3974_/Q _3448_/B _3435_/C _3437_/C vdd gnd AOI21X1
X_3366_ _4004_/Q _3369_/A vdd gnd INVX1
X_3504_ _3525_/A _3942_/Q _3504_/C _3505_/B vdd gnd OAI21X1
X_2317_ _3999_/Q _3270_/A _2355_/A vdd gnd NOR2X1
X_3297_ _4066_/Q _3304_/A vdd gnd INVX1
X_2179_ _3823_/Q _3375_/B _2472_/B vdd gnd NAND2X1
XFILL_0__3709_ vdd gnd FILL
X_2248_ _3177_/A _3841_/A _3090_/A _3403_/B _2249_/B vdd gnd OAI22X1
XFILL_0__2040_ vdd gnd FILL
X_3220_ _4064_/Q _3308_/A vdd gnd INVX1
X_2102_ _2102_/A _2134_/B _4057_/D vdd gnd AND2X2
X_2033_ _2049_/A _2033_/B _2036_/A vdd gnd NOR2X1
X_3082_ _4034_/Q _3918_/Q _3082_/S _3083_/B vdd gnd MUX2X1
X_3151_ _3298_/B _3695_/B _3289_/C _3739_/D vdd gnd MUX2X1
X_3984_ _3984_/D _3996_/CLK _3984_/Q vdd gnd DFFPOSX1
X_2935_ _2935_/A _2939_/A _3845_/A _2936_/C vdd gnd OAI21X1
XFILL_0__3425_ vdd gnd FILL
X_2797_ _2801_/A _2797_/B _2797_/C _2798_/A vdd gnd OAI21X1
X_2866_ _3881_/Q _3879_/Q _2890_/S _2868_/B vdd gnd MUX2X1
X_3349_ _3349_/A _3351_/A _3349_/S _4026_/D vdd gnd MUX2X1
X_3418_ _3980_/Q _3418_/B _3420_/A vdd gnd NOR2X1
X_2651_ _3973_/Q _2683_/A vdd gnd INVX1
X_2720_ _3955_/Q _2784_/B _2721_/C vdd gnd NAND2X1
X_2582_ _4009_/Q _2583_/B vdd gnd INVX1
XFILL_0__2925_ vdd gnd FILL
X_3203_ _3716_/Q _3205_/A vdd gnd INVX1
XFILL_0__2856_ vdd gnd FILL
X_3065_ _3065_/A _3065_/B _3073_/A _3777_/D vdd gnd AOI21X1
X_3134_ _3134_/A _3290_/B _3208_/C _3743_/D vdd gnd OAI21X1
X_2016_ _4079_/Q _3940_/Q _2136_/S _2017_/B vdd gnd MUX2X1
XFILL_0__3408_ vdd gnd FILL
X_3967_ _3967_/D _3979_/CLK _3967_/Q vdd gnd DFFPOSX1
X_2918_ _3854_/Q _3852_/Q _2918_/S _2920_/B vdd gnd MUX2X1
XFILL_0__3339_ vdd gnd FILL
X_3898_ _3906_/R vdd _3898_/D _3954_/CLK _3898_/Q vdd gnd DFFSR
X_2849_ _2849_/A _2917_/B _3893_/D vdd gnd AND2X2
XBUFX2_insert104 _2289_/Y _3306_/A vdd gnd BUFX2
XBUFX2_insert159 _2694_/Y _2784_/B vdd gnd BUFX2
XFILL_0__2710_ vdd gnd FILL
X_3821_ _3821_/D _3821_/CLK _3821_/Q vdd gnd DFFPOSX1
X_3752_ _3752_/D _3885_/CLK _3752_/Q vdd gnd DFFPOSX1
XFILL_0__3124_ vdd gnd FILL
X_2565_ _2958_/A _3032_/B vdd gnd INVX1
X_2703_ _3961_/Q _3959_/Q _2767_/S _2705_/B vdd gnd MUX2X1
X_2634_ _2937_/S _3118_/C _2638_/C vdd gnd NOR2X1
X_3683_ _3684_/A _3684_/B _3700_/Y _3686_/B vdd gnd OAI21X1
X_2496_ _3983_/Q _2671_/B vdd gnd INVX1
XFILL_0__2839_ vdd gnd FILL
X_3117_ _3117_/A _3117_/B _3814_/A _3118_/B vdd gnd OAI21X1
X_3048_ _3070_/B _3048_/B _3063_/C _3049_/A vdd gnd NAND3X1
X_4097_ _4097_/D _4099_/CLK _4097_/Q vdd gnd DFFPOSX1
XFILL128850x36150 vdd gnd FILL
XFILL128850x126150 vdd gnd FILL
XFILL_0__2624_ vdd gnd FILL
X_4020_ _4020_/D _4021_/CLK _4020_/Q vdd gnd DFFPOSX1
X_2350_ _3783_/Q _2353_/C vdd gnd INVX1
X_2281_ _3785_/Q _2292_/C vdd gnd INVX1
XFILL_0__3673_ vdd gnd FILL
XFILL_0__2555_ vdd gnd FILL
XBUFX2_insert4 _3404_/Y _3549_/S vdd gnd BUFX2
XFILL_0__3038_ vdd gnd FILL
XFILL_0__3107_ vdd gnd FILL
X_3804_ _3804_/D _3900_/CLK _3804_/Q vdd gnd DFFPOSX1
X_1996_ _1996_/A _1996_/B _2045_/B _1997_/C vdd gnd OAI21X1
X_3735_ _3735_/D _3162_/A _3735_/Q vdd gnd DFFPOSX1
X_2548_ _2548_/A _2548_/B _3062_/C _4020_/D vdd gnd AOI21X1
X_2617_ _2967_/C _3999_/D vdd gnd INVX1
X_3597_ _3599_/C _3613_/B _3597_/C _3613_/D _3835_/D vdd gnd OAI22X1
X_3666_ _3765_/Q _3666_/Y vdd gnd INVX1
X_2479_ _3786_/Q _3623_/A vdd gnd INVX1
X_3520_ _3521_/A _3650_/B _3521_/C vdd gnd NAND2X1
X_2333_ _3777_/Q _2529_/A _2333_/C _2334_/C vdd gnd AOI21X1
X_2402_ _3247_/A _2405_/B vdd gnd INVX1
X_3382_ _3382_/A _3382_/B _3849_/A _3383_/B vdd gnd AOI21X1
X_3451_ _3966_/Q _3454_/A vdd gnd INVX1
X_4003_ _4003_/D _4025_/CLK _4003_/Q vdd gnd DFFPOSX1
X_2264_ _4074_/Q _3277_/B vdd gnd INVX1
XFILL_0__3587_ vdd gnd FILL
X_2195_ _2195_/A _2195_/B _2195_/C _4034_/D vdd gnd AOI21X1
XFILL_0__2538_ vdd gnd FILL
XFILL_0__2469_ vdd gnd FILL
X_3718_ _3718_/D _3821_/CLK _3718_/Q vdd gnd DFFPOSX1
X_1979_ _2177_/C _1979_/B _1980_/B vdd gnd NOR2X1
X_3649_ _3649_/A _3649_/B _3712_/S _3898_/D vdd gnd MUX2X1
XCLKBUF1_insert129 CLKBUF1_insert181/Y _3943_/CLK vdd gnd CLKBUF1
XCLKBUF1_insert118 CLKBUF1_insert183/Y _3889_/CLK vdd gnd CLKBUF1
XFILL_0__3441_ vdd gnd FILL
XFILL_0__2323_ vdd gnd FILL
X_2951_ _3801_/Q _3023_/C vdd gnd INVX1
XFILL_0__2254_ vdd gnd FILL
XCLKBUF1_insert55 i_clk_fast _4087_/CLK vdd gnd CLKBUF1
XFILL_0__3372_ vdd gnd FILL
X_1902_ _3808_/Q _3607_/A vdd gnd INVX1
X_2882_ _3873_/Q _3871_/Q _2890_/S _2884_/B vdd gnd MUX2X1
X_3503_ _3525_/A _3646_/B _3504_/C vdd gnd NAND2X1
X_2316_ _2316_/A _2316_/B _2359_/C vdd gnd NOR2X1
X_3296_ _3857_/Y _3296_/B _3296_/C _4066_/D vdd gnd OAI21X1
XFILL_0__1969_ vdd gnd FILL
X_3434_ _3434_/A _3448_/B _3551_/A _3435_/C vdd gnd OAI21X1
X_3365_ _3365_/A _3367_/A _3365_/S _4006_/D vdd gnd MUX2X1
X_2247_ _2419_/C _3090_/A vdd gnd INVX1
X_2178_ _3997_/Q _3375_/B vdd gnd INVX1
XFILL_0__2941_ vdd gnd FILL
XFILL_0__2872_ vdd gnd FILL
X_3150_ _3713_/Q _3694_/A _3150_/C _3695_/B vdd gnd OAI21X1
X_2101_ _3630_/B _2125_/B _2101_/C _2102_/A vdd gnd OAI21X1
X_2032_ _4075_/Q _3944_/Q _2064_/S _2033_/B vdd gnd MUX2X1
X_3081_ _3081_/A _3165_/C _3765_/D vdd gnd AND2X2
X_3983_ _3983_/D _4025_/CLK _3983_/Q vdd gnd DFFPOSX1
X_2934_ _2934_/A _2934_/B _2934_/C _2935_/A vdd gnd OAI21X1
X_2865_ _2865_/A _3165_/C _3885_/D vdd gnd AND2X2
XFILL_0__2237_ vdd gnd FILL
XFILL_0__3286_ vdd gnd FILL
X_2796_ _3917_/Q _2801_/A _2797_/C vdd gnd NAND2X1
XFILL_0__2168_ vdd gnd FILL
X_3348_ _4026_/Q _3351_/A vdd gnd INVX1
X_3417_ _3465_/A _3627_/B _3422_/C vdd gnd NAND2X1
X_3279_ _3648_/A _3648_/B _3279_/S _3295_/B vdd gnd MUX2X1
XFILL_0__3071_ vdd gnd FILL
XFILL_0__3140_ vdd gnd FILL
X_2650_ _3969_/Q _2655_/A vdd gnd INVX1
X_2581_ _2581_/A _2581_/B _3013_/C _4011_/D vdd gnd AOI21X1
XFILL_0__2022_ vdd gnd FILL
X_3202_ _3202_/A _3293_/B _3202_/C _3202_/D _3718_/D vdd gnd AOI22X1
X_3133_ _3306_/A _3691_/A _3208_/C vdd gnd OR2X2
XFILL_0__2786_ vdd gnd FILL
X_3064_ _3777_/Q _3064_/B _3065_/B vdd gnd NAND2X1
X_2015_ _4077_/Q _3640_/B vdd gnd INVX1
X_2917_ _2917_/A _2917_/B _3858_/D vdd gnd AND2X2
X_2848_ _2864_/A _2848_/B _2848_/C _2849_/A vdd gnd OAI21X1
X_3897_ _3897_/D _3917_/CLK _3897_/Q vdd gnd DFFPOSX1
X_3966_ _3966_/D _3985_/CLK _3966_/Q vdd gnd DFFPOSX1
X_2779_ _3923_/Q _3921_/Q _2906_/S _2781_/B vdd gnd MUX2X1
XBUFX2_insert105 _2289_/Y _3281_/C vdd gnd BUFX2
XFILL_0__2640_ vdd gnd FILL
XFILL_0__2571_ vdd gnd FILL
X_2702_ _2702_/A _2782_/B _3965_/D vdd gnd AND2X2
X_3682_ _3794_/Q _3684_/A vdd gnd INVX1
X_3751_ _3914_/R vdd _3751_/D _4092_/CLK _3751_/Q vdd gnd DFFSR
X_3820_ _3820_/D _4008_/CLK _3820_/Q vdd gnd DFFPOSX1
X_2564_ _3797_/Q _3014_/B _2958_/A vdd gnd NAND2X1
X_2633_ _3981_/Q _2633_/B _2639_/A vdd gnd NAND2X1
X_2495_ _3775_/Q _3067_/B vdd gnd INVX1
XFILL_0__2907_ vdd gnd FILL
X_4096_ _4096_/D _3685_/A _4096_/Q vdd gnd DFFPOSX1
X_3116_ _3116_/A _3120_/A _3116_/C _3752_/D vdd gnd OAI21X1
X_3047_ _3787_/Q _3064_/B _3049_/B vdd gnd NAND2X1
X_3949_ _3949_/D _3955_/CLK _3949_/Q vdd gnd DFFPOSX1
X_2280_ _3785_/Q _2280_/B _2280_/C _2296_/B vdd gnd NAND3X1
X_3803_ _3803_/D _3840_/CLK _3803_/Q vdd gnd DFFPOSX1
XFILL_0__2485_ vdd gnd FILL
XBUFX2_insert5 _2413_/Y _3349_/S vdd gnd BUFX2
X_2616_ _2616_/A _2952_/C _4001_/D vdd gnd AND2X2
X_1995_ _2083_/A _1995_/B _1996_/B vdd gnd NOR2X1
X_3665_ _3745_/Q _4032_/Q _3666_/Y _3665_/Y vdd gnd OAI21X1
X_3734_ _3906_/R vdd _3734_/D _3940_/CLK _3734_/Q vdd gnd DFFSR
X_2547_ _3070_/B _2589_/A _3063_/C _2548_/A vdd gnd NAND3X1
X_3596_ _3835_/Q _3599_/C vdd gnd INVX1
X_2478_ _2478_/A _2478_/B _3623_/B _3623_/C vdd gnd OAI21X1
X_4079_ _4079_/D _4087_/CLK _4079_/Q vdd gnd DFFPOSX1
XFILL_0__2270_ vdd gnd FILL
X_2332_ _4021_/Q _2368_/B _2333_/C vdd gnd NAND2X1
X_2401_ _3853_/Y _3849_/Y _3247_/A vdd gnd NOR2X1
X_3381_ _3381_/A _3381_/B _3853_/Y _3382_/B vdd gnd AOI21X1
X_3450_ _3553_/B _3450_/B _3450_/C _3968_/D vdd gnd OAI21X1
XFILL_0__2606_ vdd gnd FILL
X_2263_ _3265_/A _3282_/D _2271_/A vdd gnd NAND2X1
X_4002_ _4002_/D _4041_/CLK _4002_/Q vdd gnd DFFPOSX1
X_2194_ _4034_/Q _3084_/S _2195_/B vdd gnd NAND2X1
XFILL_0__3655_ vdd gnd FILL
X_3579_ _3581_/C _3585_/B _3579_/C _3583_/D _3872_/D vdd gnd OAI22X1
X_1978_ _4019_/Q _3851_/Q _2082_/S _1979_/B vdd gnd MUX2X1
X_3717_ _3717_/D _4099_/CLK _3717_/Q vdd gnd DFFPOSX1
X_3648_ _3648_/A _3648_/B _3650_/S _3902_/D vdd gnd MUX2X1
XCLKBUF1_insert119 CLKBUF1_insert180/Y _4072_/CLK vdd gnd CLKBUF1
X_2950_ _2950_/A _2950_/B _3003_/C _3840_/D vdd gnd AOI21X1
X_2881_ _2881_/A _3165_/C _3877_/D vdd gnd AND2X2
X_1901_ _1901_/A _3662_/Y _3084_/S vdd gnd NAND2X1
XFILL_0__2184_ vdd gnd FILL
X_3433_ _3433_/A _3433_/B _3434_/A vdd gnd NOR2X1
X_3502_ _3940_/Q _3505_/A vdd gnd INVX1
X_2315_ _3779_/Q _2608_/A _2315_/C _2316_/B vdd gnd OAI21X1
X_2246_ _3117_/A _3117_/B _2419_/C vdd gnd NOR2X1
X_3364_ _4006_/Q _3367_/A vdd gnd INVX1
X_3295_ _3295_/A _3295_/B _3295_/C _4066_/Q _3296_/C vdd gnd AOI22X1
XFILL_0__3638_ vdd gnd FILL
XFILL_0__3569_ vdd gnd FILL
X_2177_ _3429_/A _2187_/S _2177_/C _2181_/B vdd gnd OAI21X1
X_2100_ _2100_/A _2100_/B _2125_/B _2101_/C vdd gnd OAI21X1
X_3080_ _3083_/A _3080_/B _3080_/C _3081_/A vdd gnd OAI21X1
X_3982_ _3982_/D _4100_/CLK _3982_/Q vdd gnd DFFPOSX1
XFILL_0__3423_ vdd gnd FILL
XFILL_0__3354_ vdd gnd FILL
X_2031_ _4073_/Q _3638_/B vdd gnd INVX1
X_2795_ _3915_/Q _3913_/Q _2826_/S _2797_/B vdd gnd MUX2X1
XFILL_0__2305_ vdd gnd FILL
X_2933_ _2933_/A _2933_/B _3118_/C _3852_/D vdd gnd AOI21X1
X_2864_ _2864_/A _2864_/B _2864_/C _2865_/A vdd gnd OAI21X1
X_3416_ _3470_/S _3421_/C _3416_/C _3416_/D _3985_/D vdd gnd AOI22X1
X_3347_ _3347_/A _3349_/A _3349_/S _4029_/D vdd gnd MUX2X1
X_3278_ _3902_/Q _3648_/A vdd gnd INVX1
X_2229_ _3117_/B _2230_/C vdd gnd INVX1
XFILL_0__2923_ vdd gnd FILL
X_2580_ _3292_/B _3292_/A _2581_/A vdd gnd NAND2X1
X_3063_ _3999_/Q _3070_/B _3063_/C _3065_/A vdd gnd NAND3X1
X_3201_ _3720_/Q _3213_/B _3213_/C _3202_/D vdd gnd OAI21X1
XFILL_0__2854_ vdd gnd FILL
X_3132_ _4081_/Q _3313_/S _3132_/C _3691_/A vdd gnd OAI21X1
X_3965_ _3965_/D _3986_/CLK _3965_/Q vdd gnd DFFPOSX1
XFILL_0__3337_ vdd gnd FILL
X_2014_ _2014_/A _2189_/C _4079_/D vdd gnd AND2X2
X_2778_ _2778_/A _2913_/B _3927_/D vdd gnd AND2X2
XFILL_0__2219_ vdd gnd FILL
X_2916_ _2926_/B _2916_/B _2916_/C _2917_/A vdd gnd OAI21X1
X_2847_ _3893_/Q _2864_/A _2848_/C vdd gnd NAND2X1
X_3896_ _3896_/D _4045_/CLK _3896_/Q vdd gnd DFFPOSX1
XFILL_0__3268_ vdd gnd FILL
XBUFX2_insert106 _2289_/Y _3276_/A vdd gnd BUFX2
X_2701_ _2769_/A _2701_/B _2701_/C _2702_/A vdd gnd OAI21X1
X_2632_ _2632_/A _2931_/B vdd gnd INVX2
XFILL_0__3053_ vdd gnd FILL
X_3681_ _3828_/Q _3828_/D vdd gnd INVX1
X_3750_ _3750_/D _4053_/CLK _3814_/A vdd gnd DFFPOSX1
XFILL_0__2004_ vdd gnd FILL
XFILL_0__3122_ vdd gnd FILL
X_2563_ _4014_/Q _3015_/B _3014_/B vdd gnd NOR2X1
X_2494_ _2494_/A _3076_/A _2494_/C _2662_/A vdd gnd OAI21X1
X_3046_ _3046_/A _3046_/B _3062_/C _3789_/D vdd gnd AOI21X1
XFILL_0__2768_ vdd gnd FILL
XFILL_0__2699_ vdd gnd FILL
XFILL_0__2837_ vdd gnd FILL
X_3115_ _3115_/A _3115_/B _3115_/C _3116_/C vdd gnd OAI21X1
X_4095_ _4095_/D _4099_/CLK _4095_/Q vdd gnd DFFPOSX1
X_3948_ _3948_/D _3964_/CLK _3948_/Q vdd gnd DFFPOSX1
X_3879_ _3879_/D _3889_/CLK _3879_/Q vdd gnd DFFPOSX1
XFILL_0__2622_ vdd gnd FILL
XFILL_0__2553_ vdd gnd FILL
XBUFX2_insert6 _2413_/Y _3372_/A vdd gnd BUFX2
XFILL_0__3671_ vdd gnd FILL
X_3802_ _3845_/A _3802_/Y vdd gnd INVX8
X_1994_ _4024_/Q _3859_/Q _2090_/S _1995_/B vdd gnd MUX2X1
XFILL_0__3036_ vdd gnd FILL
X_2615_ _2637_/A _2622_/B _2615_/C _2616_/A vdd gnd OAI21X1
X_3595_ _3597_/C _3614_/B _3595_/C _3614_/D _3839_/D vdd gnd OAI22X1
X_3733_ _3733_/D _4080_/CLK _3853_/A vdd gnd DFFPOSX1
X_3664_ _3665_/Y _3667_/Y _3827_/Q _3664_/Y vdd gnd OAI21X1
X_2546_ _3066_/A _3066_/B _3063_/C vdd gnd AND2X2
X_2477_ _3439_/B _2477_/B _3545_/A _2477_/D _2478_/B vdd gnd OAI22X1
X_3029_ _3799_/Q _3029_/B _3031_/C _3030_/A vdd gnd OAI21X1
X_4078_ _4078_/D _3685_/A _4078_/Q vdd gnd DFFPOSX1
X_2400_ _3731_/Q _3178_/A vdd gnd INVX1
XBUFX2_insert90 _2274_/Y _3305_/B vdd gnd BUFX2
X_2331_ _4028_/Q _2368_/B vdd gnd INVX1
X_4001_ _4001_/D _4014_/CLK _4001_/Q vdd gnd DFFPOSX1
X_2262_ _4072_/Q _3282_/D vdd gnd INVX1
X_3380_ _3738_/Q _3739_/Q _3381_/B vdd gnd NAND2X1
XFILL_0__1984_ vdd gnd FILL
XFILL_0__2536_ vdd gnd FILL
XFILL_0__3585_ vdd gnd FILL
X_2193_ _2193_/A _2193_/B _2195_/A vdd gnd NAND2X1
X_3716_ _3716_/D _3821_/CLK _3716_/Q vdd gnd DFFPOSX1
XFILL_0__2467_ vdd gnd FILL
XFILL_0__2398_ vdd gnd FILL
X_1977_ _2049_/A _1977_/B _1980_/A vdd gnd NOR2X1
X_2529_ _2529_/A _2529_/B _2533_/A _2605_/A _2532_/B vdd gnd OAI22X1
X_3578_ _3872_/Q _3581_/C vdd gnd INVX1
X_3647_ _3647_/A _3647_/B _3653_/S _3906_/D vdd gnd MUX2X1
XFILL_0__2321_ vdd gnd FILL
XFILL_0__3370_ vdd gnd FILL
X_2880_ _2880_/A _2880_/B _2880_/C _2881_/A vdd gnd OAI21X1
XFILL_0__2252_ vdd gnd FILL
X_1900_ _1900_/A _1900_/B _1901_/A vdd gnd NAND2X1
X_3432_ _3442_/A _3432_/B _3433_/A vdd gnd NOR2X1
X_3363_ _3363_/A _3365_/A _3365_/S _4008_/D vdd gnd MUX2X1
X_3501_ _3501_/A _3501_/B _3549_/S _3942_/D vdd gnd MUX2X1
X_2314_ _3787_/Q _2314_/B _2314_/C _2315_/C vdd gnd NAND3X1
XFILL_0__3706_ vdd gnd FILL
X_2245_ _3754_/Q _3117_/A vdd gnd INVX1
X_2176_ _3980_/Q _3429_/A vdd gnd INVX2
XFILL_0__1967_ vdd gnd FILL
XFILL_0__1898_ vdd gnd FILL
X_3294_ _3862_/Y _3295_/A _3295_/C vdd gnd NOR2X1
XFILL_0__2870_ vdd gnd FILL
X_2030_ _2030_/A _2134_/B _4075_/D vdd gnd AND2X2
X_3981_ _3981_/D _2373_/A _3981_/Q vdd gnd DFFPOSX1
X_2932_ _3852_/Q _2939_/A _2933_/A vdd gnd NAND2X1
XFILL_0__3284_ vdd gnd FILL
X_2794_ _2794_/A _2913_/B _3919_/D vdd gnd AND2X2
X_2863_ _3885_/Q _2864_/A _2864_/C vdd gnd NAND2X1
XFILL_0__2235_ vdd gnd FILL
XFILL_0__2097_ vdd gnd FILL
XFILL_0__2166_ vdd gnd FILL
X_3346_ _4029_/Q _3349_/A vdd gnd INVX1
X_3415_ _3465_/A _4048_/Q _3553_/B _3416_/C vdd gnd AOI21X1
X_3277_ _3316_/A _3277_/B _3277_/C _4074_/D vdd gnd AOI21X1
X_2228_ _3866_/B _3756_/Q _3755_/Q _3117_/B vdd gnd NAND3X1
X_2159_ _3997_/Q _3823_/Q _2159_/C _2160_/B vdd gnd OAI21X1
XFILL129150x68550 vdd gnd FILL
XFILL129150x100950 vdd gnd FILL
XFILL_0__2020_ vdd gnd FILL
X_3200_ _3718_/Q _3202_/A vdd gnd INVX1
X_3062_ _3062_/A _3062_/B _3062_/C _3779_/D vdd gnd AOI21X1
X_2013_ _3641_/B _2161_/B _2013_/C _2014_/A vdd gnd OAI21X1
X_3131_ _3313_/S _3642_/A _3132_/C vdd gnd NAND2X1
X_3895_ _3895_/D _3917_/CLK _3895_/Q vdd gnd DFFPOSX1
X_2915_ _3858_/Q _2926_/B _2916_/C vdd gnd NAND2X1
XFILL_0__3405_ vdd gnd FILL
X_3964_ _3964_/D _3964_/CLK _3964_/Q vdd gnd DFFPOSX1
X_2777_ _2801_/A _2777_/B _2777_/C _2778_/A vdd gnd OAI21X1
X_2846_ _3891_/Q _3889_/Q _2918_/S _2848_/B vdd gnd MUX2X1
X_3329_ _3329_/A _3331_/A _3377_/S _4047_/D vdd gnd MUX2X1
XBUFX2_insert107 _2289_/Y _3289_/C vdd gnd BUFX2
X_2631_ _3996_/Q _2631_/B _2631_/C _3996_/D vdd gnd AOI21X1
X_2700_ _3965_/Q _2769_/A _2701_/C vdd gnd NAND2X1
X_2562_ _4012_/Q _3015_/B vdd gnd INVX2
X_3680_ _3680_/A _3680_/B _3833_/D vdd gnd NOR2X1
XFILL_0__2905_ vdd gnd FILL
X_2493_ _2493_/A _2493_/B _2493_/C _2494_/C vdd gnd AOI21X1
X_3045_ _3789_/Q _3064_/B _3046_/B vdd gnd NAND2X1
X_4094_ _4094_/D _3685_/A _4094_/Q vdd gnd DFFPOSX1
X_3114_ _3114_/A _3118_/A _3115_/C vdd gnd NOR2X1
X_3947_ _3947_/D _3955_/CLK _3947_/Q vdd gnd DFFPOSX1
XFILL_0__3319_ vdd gnd FILL
X_3878_ vdd _3906_/R _3878_/D _3997_/CLK _3878_/Q vdd gnd DFFSR
X_2829_ _2829_/A _3845_/A _3903_/D vdd gnd AND2X2
XBUFX2_insert7 _2413_/Y _3377_/S vdd gnd BUFX2
X_3801_ _3801_/D _3840_/CLK _3801_/Q vdd gnd DFFPOSX1
XFILL_0__3104_ vdd gnd FILL
X_3732_ _3732_/D _4098_/CLK _3732_/Q vdd gnd DFFPOSX1
X_1993_ _2169_/A _1993_/B _1996_/A vdd gnd NOR2X1
X_2545_ _4020_/Q _3064_/B _2548_/B vdd gnd NAND2X1
X_2614_ _3992_/Q _2813_/S _2637_/A _2614_/D _2615_/C vdd gnd AOI22X1
X_3594_ _3839_/Q _3597_/C vdd gnd INVX1
X_3663_ _3827_/Q _3663_/Y vdd gnd INVX1
XFILL_0__2819_ vdd gnd FILL
X_2476_ _3997_/Q _3823_/Q _2477_/B vdd gnd NAND2X1
X_3028_ _3029_/B _3799_/Q _3031_/B vdd gnd AND2X2
X_4077_ _4077_/D _4093_/CLK _4077_/Q vdd gnd DFFPOSX1
XFILL128250x108150 vdd gnd FILL
XBUFX2_insert80 _3802_/Y _3073_/A vdd gnd BUFX2
XBUFX2_insert91 _2274_/Y _3009_/B vdd gnd BUFX2
X_2330_ _3999_/Q _3846_/Q _2330_/C _2342_/A vdd gnd OAI21X1
XFILL_0__2604_ vdd gnd FILL
X_2261_ _4060_/Q _3265_/A vdd gnd INVX1
X_2192_ _3083_/A _2192_/B _2192_/C _2193_/A vdd gnd OAI21X1
X_4000_ _4000_/D _3737_/D _4000_/Q vdd gnd DFFPOSX1
XFILL_0__3653_ vdd gnd FILL
XFILL_0__3018_ vdd gnd FILL
X_1976_ _4089_/Q _3930_/Q _2187_/S _1977_/B vdd gnd MUX2X1
X_3715_ _3715_/D _4099_/CLK _3715_/Q vdd gnd DFFPOSX1
X_2528_ _2528_/A _2528_/B _2605_/A vdd gnd NOR2X1
X_3577_ _3579_/C _3609_/B _3577_/C _3583_/D _3876_/D vdd gnd OAI22X1
X_3646_ _3646_/A _3646_/B _3646_/S _3910_/D vdd gnd MUX2X1
X_2459_ _2459_/A _2459_/B _3106_/B vdd gnd NAND2X1
XCLKBUF1_insert47 i_clk_fast _4093_/CLK vdd gnd CLKBUF1
X_3500_ _3548_/A _3944_/Q _3500_/C _3501_/B vdd gnd OAI21X1
X_2313_ _2313_/A _2590_/A _2314_/C vdd gnd NAND2X1
X_3431_ _3431_/A _3431_/B _3445_/B _3974_/D vdd gnd MUX2X1
X_3362_ _4008_/Q _3365_/A vdd gnd INVX1
X_3293_ _3293_/A _3293_/B _3293_/C _3293_/D _4068_/D vdd gnd AOI22X1
XFILL_0__3567_ vdd gnd FILL
X_2175_ _2175_/A _2175_/B _2181_/A vdd gnd NOR2X1
XFILL_0__3636_ vdd gnd FILL
X_2244_ _2244_/A _2412_/A _3403_/B vdd gnd NAND2X1
XFILL_0__2518_ vdd gnd FILL
XFILL_0__2449_ vdd gnd FILL
XFILL_0__3498_ vdd gnd FILL
X_1959_ _4091_/Q _3647_/B vdd gnd INVX1
X_3629_ _3629_/A _3629_/B _3646_/S _3776_/D vdd gnd MUX2X1
XFILL_0__3421_ vdd gnd FILL
XFILL_0__2303_ vdd gnd FILL
X_2931_ _2937_/S _2931_/B _2931_/C _2933_/B vdd gnd OAI21X1
X_3980_ _3980_/D _3980_/CLK _3980_/Q vdd gnd DFFPOSX1
XFILL_0__3352_ vdd gnd FILL
X_2793_ _2801_/A _2793_/B _2793_/C _2794_/A vdd gnd OAI21X1
X_2862_ _3883_/Q _3881_/Q _2890_/S _2864_/B vdd gnd MUX2X1
XFILL_0__2998_ vdd gnd FILL
X_3276_ _3276_/A _3276_/B _3276_/C _3277_/C vdd gnd OAI21X1
X_3345_ _3345_/A _3347_/A _3349_/S _4031_/D vdd gnd MUX2X1
XFILL_0__1949_ vdd gnd FILL
X_3414_ _3414_/A _3414_/B _3416_/D vdd gnd OR2X2
X_2227_ _2227_/A _2227_/B _3849_/A _2412_/A vdd gnd OAI21X1
X_2089_ _2129_/A _2089_/B _2092_/A vdd gnd NOR2X1
X_2158_ _3083_/C _2159_/C vdd gnd INVX1
XFILL_0__2783_ vdd gnd FILL
XFILL_0__2921_ vdd gnd FILL
XFILL_0__2852_ vdd gnd FILL
X_3130_ _3736_/Q _3642_/A vdd gnd INVX1
X_3061_ _3070_/B _3061_/B _3063_/C _3062_/A vdd gnd NAND3X1
X_2012_ _2012_/A _2012_/B _2161_/B _2013_/C vdd gnd OAI21X1
X_3963_ _3963_/D _3979_/CLK _3963_/Q vdd gnd DFFPOSX1
XFILL_0__2217_ vdd gnd FILL
X_2845_ _2845_/A _2913_/B _3895_/D vdd gnd AND2X2
X_2914_ _3856_/Q _3854_/Q _2918_/S _2916_/B vdd gnd MUX2X1
XFILL_0__3197_ vdd gnd FILL
XFILL_0__3266_ vdd gnd FILL
XFILL_0__3335_ vdd gnd FILL
X_3894_ _3906_/R vdd _3894_/D _4072_/CLK _3894_/Q vdd gnd DFFSR
X_2776_ _3927_/Q _2792_/B _2777_/C vdd gnd NAND2X1
XFILL_0__2148_ vdd gnd FILL
X_3259_ _3259_/A _3260_/B vdd gnd INVX1
X_3328_ _4047_/Q _3331_/A vdd gnd INVX1
XBUFX2_insert108 _2289_/Y _3314_/S vdd gnd BUFX2
XFILL128550x46950 vdd gnd FILL
XFILL_0__3051_ vdd gnd FILL
XFILL_0__3120_ vdd gnd FILL
X_2630_ _3996_/Q _2631_/B _2946_/C _2631_/C vdd gnd OAI21X1
X_2561_ _3024_/A _2561_/B _3032_/A vdd gnd NOR2X1
X_2492_ _2492_/A _2492_/B _2492_/C _2493_/C vdd gnd OAI21X1
XFILL_0__2002_ vdd gnd FILL
XFILL_0__2766_ vdd gnd FILL
X_3113_ _3845_/A _3853_/A _3114_/A vdd gnd NAND2X1
X_4093_ _4093_/D _4093_/CLK _4093_/Q vdd gnd DFFPOSX1
X_3044_ _3070_/B _3044_/B _3063_/C _3046_/A vdd gnd NAND3X1
XFILL_0__2697_ vdd gnd FILL
X_2828_ _2926_/B _2828_/B _2828_/C _2829_/A vdd gnd OAI21X1
X_3877_ _3877_/D _3889_/CLK _3877_/Q vdd gnd DFFPOSX1
X_3946_ _3946_/D _4035_/CLK _3946_/Q vdd gnd DFFPOSX1
X_2759_ _3933_/Q _3931_/Q _2767_/S _2761_/B vdd gnd MUX2X1
XFILL_0__2620_ vdd gnd FILL
XBUFX2_insert8 _2413_/Y _3365_/S vdd gnd BUFX2
XFILL_0__2551_ vdd gnd FILL
XFILL_0__2482_ vdd gnd FILL
XFILL_0__3034_ vdd gnd FILL
X_3731_ _3731_/D _4098_/CLK _3731_/Q vdd gnd DFFPOSX1
X_1992_ _4085_/Q _3934_/Q _2136_/S _1993_/B vdd gnd MUX2X1
X_3662_ _3665_/Y _3667_/Y _3662_/Y vdd gnd NOR2X1
X_3800_ _3800_/D _3737_/D _3800_/Q vdd gnd DFFPOSX1
X_2544_ _3066_/C _2544_/B _2544_/C _4021_/D vdd gnd AOI21X1
X_2613_ _2810_/C _2614_/D vdd gnd INVX1
X_3593_ _3595_/C _3614_/B _3593_/C _3614_/D _3843_/D vdd gnd OAI22X1
X_2475_ _3375_/B _3393_/B _2477_/D vdd gnd NAND2X1
X_4076_ _4076_/D _4076_/CLK _4076_/Q vdd gnd DFFPOSX1
X_3027_ _3027_/A _3801_/D vdd gnd INVX1
X_3929_ _3929_/D _3959_/CLK _3929_/Q vdd gnd DFFPOSX1
XBUFX2_insert70 _3979_/Q _2937_/S vdd gnd BUFX2
XBUFX2_insert92 _2274_/Y _3708_/B vdd gnd BUFX2
XFILL_0__1982_ vdd gnd FILL
XBUFX2_insert81 _3802_/Y _2195_/C vdd gnd BUFX2
X_2260_ _3862_/Y _3403_/B _3617_/C vdd gnd NAND2X1
X_2191_ _4036_/Q _3987_/Q _2191_/S _2192_/B vdd gnd MUX2X1
XFILL_0__2396_ vdd gnd FILL
XFILL_0__2465_ vdd gnd FILL
X_3714_ _3714_/D _3821_/CLK _3714_/Q vdd gnd DFFPOSX1
X_3645_ _3645_/A _3645_/B _3709_/B _3914_/D vdd gnd MUX2X1
X_1975_ _4087_/Q _3645_/B vdd gnd INVX1
X_2527_ _3771_/Q _2589_/A _2533_/B vdd gnd NAND2X1
X_2458_ _2458_/A _2459_/A _2459_/B _3104_/A vdd gnd NAND3X1
X_3576_ _3876_/Q _3579_/C vdd gnd INVX1
X_2389_ _2391_/B _2675_/C _2390_/C vdd gnd OR2X2
X_4059_ _4059_/D _4073_/CLK _4059_/Q vdd gnd DFFPOSX1
XFILL128550x100950 vdd gnd FILL
XFILL_0__2250_ vdd gnd FILL
XFILL_0__2181_ vdd gnd FILL
XCLKBUF1_insert48 i_clk_fast _4073_/CLK vdd gnd CLKBUF1
XFILL_0__3704_ vdd gnd FILL
X_2312_ _2514_/A _2314_/B vdd gnd INVX1
X_3292_ _3292_/A _3292_/B _3293_/B _3293_/D vdd gnd AOI21X1
X_3430_ _3465_/A _3430_/B _3430_/C _3431_/A vdd gnd OAI21X1
XFILL_0__1965_ vdd gnd FILL
X_3361_ _3361_/A _3363_/A _3365_/S _4010_/D vdd gnd MUX2X1
X_2174_ _4038_/Q _2187_/A vdd gnd INVX1
XFILL_0__1896_ vdd gnd FILL
X_2243_ _3732_/Q _3177_/A vdd gnd INVX1
X_1958_ _1958_/A _2189_/C _4093_/D vdd gnd AND2X2
X_1889_ _3723_/Q _2196_/B vdd gnd INVX1
XFILL129150x28950 vdd gnd FILL
X_3628_ _3628_/A _3628_/B _3646_/S _3778_/D vdd gnd MUX2X1
X_3559_ _3561_/C _3609_/B _3559_/C _3583_/D _3912_/D vdd gnd OAI22X1
X_2930_ _2937_/S _2934_/A _2930_/C _2931_/C vdd gnd OAI21X1
X_2861_ _2861_/A _3165_/C _3887_/D vdd gnd AND2X2
X_2792_ _3919_/Q _2792_/B _2793_/C vdd gnd NAND2X1
XFILL_0__2095_ vdd gnd FILL
XFILL_0__2164_ vdd gnd FILL
X_3413_ _3413_/A _3413_/B _3551_/A _3414_/B vdd gnd OAI21X1
X_3275_ _3275_/A _3275_/B _3276_/A _3276_/C vdd gnd NAND3X1
X_2226_ _3742_/Q _3743_/Q _2226_/C _2227_/B vdd gnd OAI21X1
X_3344_ _4031_/Q _3347_/A vdd gnd INVX1
XFILL_0__3618_ vdd gnd FILL
X_2088_ _4061_/Q _3958_/Q _2128_/S _2089_/B vdd gnd MUX2X1
XFILL_0__3549_ vdd gnd FILL
X_2157_ _3765_/Q _3180_/B _3086_/B _3083_/C vdd gnd OAI21X1
XFILL_0_BUFX2_insert80 vdd gnd FILL
XFILL_0_BUFX2_insert91 vdd gnd FILL
X_3060_ _3779_/Q _3064_/B _3062_/B vdd gnd NAND2X1
X_2011_ _2083_/A _2011_/B _2012_/B vdd gnd NOR2X1
XFILL_0__3403_ vdd gnd FILL
X_2913_ _2913_/A _2913_/B _3860_/D vdd gnd AND2X2
X_2844_ _2912_/A _2844_/B _2844_/C _2845_/A vdd gnd OAI21X1
X_3893_ _3893_/D _3893_/CLK _3893_/Q vdd gnd DFFPOSX1
X_3962_ _3962_/D _3964_/CLK _3962_/Q vdd gnd DFFPOSX1
X_2775_ _3925_/Q _3923_/Q _2906_/S _2777_/B vdd gnd MUX2X1
X_2209_ _3069_/A _2529_/B vdd gnd INVX2
X_3189_ _3189_/A _3189_/B _3301_/B _3190_/B vdd gnd OAI21X1
X_3258_ _3258_/A _3311_/A _3258_/C _3258_/D _4080_/D vdd gnd AOI22X1
X_3327_ _3327_/A _3329_/A _3351_/S _4049_/D vdd gnd MUX2X1
XBUFX2_insert109 _2289_/Y _3213_/C vdd gnd BUFX2
X_2560_ _3799_/Q _3805_/Q _2561_/B vdd gnd NAND2X1
XFILL_0__2903_ vdd gnd FILL
X_2491_ _3853_/A _3738_/Q _3078_/B _2492_/C vdd gnd NAND3X1
X_3043_ _3043_/A _3044_/B vdd gnd INVX1
XFILL_0__2834_ vdd gnd FILL
X_3112_ _3138_/A _3621_/B _3302_/B _3115_/A vdd gnd OAI21X1
X_4092_ _4092_/D _4092_/CLK _4092_/Q vdd gnd DFFPOSX1
X_3945_ _3945_/D _3955_/CLK _3945_/Q vdd gnd DFFPOSX1
XFILL_0__3317_ vdd gnd FILL
X_2758_ _2758_/A _2782_/B _3937_/D vdd gnd AND2X2
X_2827_ _3903_/Q _2926_/B _2828_/C vdd gnd NAND2X1
XFILL_0__3248_ vdd gnd FILL
X_3876_ _3876_/D _3916_/CLK _3876_/Q vdd gnd DFFPOSX1
X_2689_ _2689_/A _2689_/B _2689_/C _3971_/D vdd gnd AOI21X1
XFILL128250x111750 vdd gnd FILL
XBUFX2_insert9 _2413_/Y _3351_/S vdd gnd BUFX2
X_2612_ _4001_/Q _2934_/B _2810_/C vdd gnd NAND2X1
XFILL_0__3102_ vdd gnd FILL
X_3592_ _3843_/Q _3595_/C vdd gnd INVX1
X_3661_ _3662_/Y _3663_/Y _3661_/Y vdd gnd AND2X2
X_1991_ _4083_/Q _3643_/B vdd gnd INVX1
X_3730_ _3730_/D _3162_/A _3730_/Q vdd gnd DFFPOSX1
X_2543_ _3070_/B _3066_/C vdd gnd INVX1
XFILL_0__3866_ vdd gnd FILL
X_2474_ _3968_/Q _3439_/B vdd gnd INVX1
X_3026_ _3026_/A _3026_/B _3027_/A vdd gnd NAND2X1
XFILL_0__2679_ vdd gnd FILL
XFILL_0__2748_ vdd gnd FILL
XFILL_0__2817_ vdd gnd FILL
X_4075_ _4075_/D _4093_/CLK _4075_/Q vdd gnd DFFPOSX1
X_3928_ _3928_/D _4035_/CLK _3928_/Q vdd gnd DFFPOSX1
X_3859_ _3859_/D _4047_/CLK _3859_/Q vdd gnd DFFPOSX1
XBUFX2_insert60 _3730_/Q _3521_/A vdd gnd BUFX2
XFILL129150x108150 vdd gnd FILL
XBUFX2_insert71 _3979_/Q _2767_/S vdd gnd BUFX2
XBUFX2_insert82 _3802_/Y _3003_/C vdd gnd BUFX2
XBUFX2_insert93 _1917_/Y _2136_/S vdd gnd BUFX2
XFILL_0__2602_ vdd gnd FILL
XFILL_0__2533_ vdd gnd FILL
XFILL_0__3582_ vdd gnd FILL
X_2190_ _2193_/B _2190_/B _2190_/C _4036_/D vdd gnd AOI21X1
XFILL_0__3651_ vdd gnd FILL
X_1974_ _1974_/A _2134_/B _4089_/D vdd gnd AND2X2
XFILL_0__3016_ vdd gnd FILL
X_3575_ _3577_/C _3585_/B _3575_/C _3583_/D _3880_/D vdd gnd OAI22X1
X_3713_ _3713_/D _4099_/CLK _3713_/Q vdd gnd DFFPOSX1
X_3644_ _3644_/A _3644_/B _3646_/S _3728_/D vdd gnd MUX2X1
X_2388_ _2388_/A _2388_/B _2391_/B vdd gnd NAND2X1
X_2526_ _2526_/A _2533_/A vdd gnd INVX1
X_2457_ _2457_/A _2457_/B _2457_/C _2459_/A vdd gnd NAND3X1
X_3009_ _3009_/A _3009_/B _3807_/Q _3013_/B vdd gnd OAI21X1
X_4058_ _4058_/D _4058_/CLK _4058_/Q vdd gnd DFFPOSX1
XCLKBUF1_insert49 i_clk_fast _4099_/CLK vdd gnd CLKBUF1
X_2311_ _2311_/A _2311_/B _2316_/A vdd gnd NAND2X1
X_3291_ _3853_/A _4080_/Q _3291_/C _3293_/C vdd gnd OAI21X1
X_3360_ _4010_/Q _3363_/A vdd gnd INVX1
X_2242_ _3732_/Q _2242_/B _2242_/C _2259_/A vdd gnd NAND3X1
XFILL_0__2516_ vdd gnd FILL
XFILL_0__3565_ vdd gnd FILL
X_2173_ _2173_/A _2173_/B _4040_/D vdd gnd AND2X2
XFILL_0__3496_ vdd gnd FILL
XFILL_0__2447_ vdd gnd FILL
XFILL_0__2378_ vdd gnd FILL
X_1957_ _3648_/B _2161_/B _1957_/C _1958_/A vdd gnd OAI21X1
X_2509_ _2529_/B _3036_/A _3071_/B _2510_/C vdd gnd OAI21X1
X_3627_ _3627_/A _3627_/B _3709_/B _3780_/D vdd gnd MUX2X1
X_3558_ _3912_/Q _3561_/C vdd gnd INVX1
X_1888_ _3159_/B _2196_/A _2198_/C _1894_/C vdd gnd NAND3X1
X_3489_ _3489_/A _3489_/B _3531_/S _3948_/D vdd gnd MUX2X1
XFILL_0__2301_ vdd gnd FILL
XFILL_0__3350_ vdd gnd FILL
X_2791_ _3917_/Q _3915_/Q _2906_/S _2793_/B vdd gnd MUX2X1
X_2860_ _2864_/A _2860_/B _2860_/C _2861_/A vdd gnd OAI21X1
XFILL_0__3281_ vdd gnd FILL
XFILL_0__2232_ vdd gnd FILL
X_3412_ _3412_/A _3412_/B _3412_/C _3413_/A vdd gnd NAND3X1
X_2225_ _3732_/Q _3743_/Q _2226_/C vdd gnd NAND2X1
XFILL_0__2996_ vdd gnd FILL
X_3343_ _3343_/A _3345_/A _3349_/S _4033_/D vdd gnd MUX2X1
XFILL_0__1947_ vdd gnd FILL
XFILL_0__1878_ vdd gnd FILL
X_3274_ _3647_/A _3647_/B _3624_/A _3276_/B vdd gnd MUX2X1
X_2087_ _4059_/Q _3631_/B vdd gnd INVX1
X_2156_ _3142_/A _3841_/Y _3086_/B vdd gnd NOR2X1
X_2989_ _3221_/A _3708_/B _3815_/Q _2993_/B vdd gnd OAI21X1
XFILL_0__2781_ vdd gnd FILL
XFILL_0__2850_ vdd gnd FILL
X_2010_ _4029_/Q _3868_/Q _2090_/S _2011_/B vdd gnd MUX2X1
X_3961_ _3961_/D _3979_/CLK _3961_/Q vdd gnd DFFPOSX1
X_2912_ _2912_/A _2912_/B _2912_/C _2913_/A vdd gnd OAI21X1
XFILL_0__3264_ vdd gnd FILL
X_2774_ _2774_/A _2782_/B _3929_/D vdd gnd AND2X2
XFILL_0__2215_ vdd gnd FILL
X_2843_ _3895_/Q _2912_/A _2844_/C vdd gnd NAND2X1
XFILL_0__3195_ vdd gnd FILL
X_3892_ _3892_/D _4045_/CLK _3892_/Q vdd gnd DFFPOSX1
XFILL_0__2077_ vdd gnd FILL
XFILL_0__2146_ vdd gnd FILL
X_3326_ _4049_/Q _3329_/A vdd gnd INVX1
X_2208_ _3773_/Q _3775_/Q _3069_/A vdd gnd NOR2X1
X_3188_ _3849_/A _3739_/Q _3189_/B vdd gnd NOR2X1
X_3257_ _4082_/Q _3257_/B _3306_/A _3258_/D vdd gnd OAI21X1
X_2139_ _2198_/C _2139_/B _2140_/B vdd gnd NOR2X1
XFILL_0__2000_ vdd gnd FILL
X_2490_ _2490_/A _2490_/B _3078_/B vdd gnd NOR2X1
XFILL_0__2764_ vdd gnd FILL
XFILL_0__2695_ vdd gnd FILL
X_3042_ _3042_/A _3042_/B _3062_/C _3791_/D vdd gnd AOI21X1
X_3111_ _3621_/B _3138_/A _3115_/B vdd gnd AND2X2
X_4091_ _4091_/D _4093_/CLK _4091_/Q vdd gnd DFFPOSX1
X_3875_ _3875_/D _3889_/CLK _3875_/Q vdd gnd DFFPOSX1
X_3944_ _3944_/D _3985_/CLK _3944_/Q vdd gnd DFFPOSX1
X_2757_ _2773_/A _2757_/B _2757_/C _2758_/A vdd gnd OAI21X1
X_2688_ _3971_/Q _2688_/B _2952_/C _2689_/C vdd gnd OAI21X1
X_2826_ _3901_/Q _3899_/Q _2826_/S _2828_/B vdd gnd MUX2X1
X_3309_ _4088_/Q _3309_/B _3314_/S _3311_/B vdd gnd MUX2X1
XFILL128250x28950 vdd gnd FILL
XFILL128850x75750 vdd gnd FILL
XFILL_0__2480_ vdd gnd FILL
X_1990_ _1990_/A _2189_/C _4085_/D vdd gnd AND2X2
X_2542_ _4021_/Q _2544_/B vdd gnd INVX1
X_2611_ _4023_/Q _2934_/B _2633_/B _2622_/B vdd gnd NAND3X1
X_3591_ _3593_/C _3614_/B _3591_/C _3614_/D _3847_/D vdd gnd OAI22X1
X_3660_ _3661_/Y _3660_/Y vdd gnd INVX1
X_2473_ _3922_/Q _3545_/A vdd gnd INVX1
X_3025_ _3025_/A _3029_/B _3026_/B vdd gnd NOR2X1
X_4074_ _4074_/D _3700_/A _4074_/Q vdd gnd DFFPOSX1
X_3927_ _3927_/D _3959_/CLK _3927_/Q vdd gnd DFFPOSX1
X_3858_ _3858_/D _3917_/CLK _3858_/Q vdd gnd DFFPOSX1
X_3789_ _3789_/D _4021_/CLK _3789_/Q vdd gnd DFFPOSX1
X_2809_ _3911_/Q _2815_/A _2812_/A vdd gnd NAND2X1
XBUFX2_insert72 _3979_/Q _2813_/S vdd gnd BUFX2
XBUFX2_insert83 _1887_/Y _2131_/A vdd gnd BUFX2
XBUFX2_insert61 _3730_/Q _3552_/A vdd gnd BUFX2
XFILL_0__1980_ vdd gnd FILL
XBUFX2_insert94 _1917_/Y _2064_/S vdd gnd BUFX2
XFILL_0__2463_ vdd gnd FILL
XFILL_0__2394_ vdd gnd FILL
X_1973_ _3646_/B _2053_/B _1973_/C _1974_/A vdd gnd OAI21X1
X_3712_ _3712_/A _3712_/B _3712_/S _3790_/D vdd gnd MUX2X1
X_2525_ _2525_/A _2525_/B _2535_/A vdd gnd NAND2X1
X_3574_ _3880_/Q _3577_/C vdd gnd INVX1
X_3643_ _3643_/A _3643_/B _3653_/S _3734_/D vdd gnd MUX2X1
X_2387_ _3846_/Q _3996_/Q _2388_/B vdd gnd NOR2X1
X_2456_ _3619_/B _2456_/B _2459_/B vdd gnd NAND2X1
X_3008_ _3196_/C _3008_/B _3013_/C _3809_/D vdd gnd AOI21X1
X_4057_ _4057_/D _4073_/CLK _4057_/Q vdd gnd DFFPOSX1
X_2310_ _3783_/Q _2310_/B _2310_/C _2311_/B vdd gnd NAND3X1
X_3290_ _3853_/A _3290_/B _3296_/B _3291_/C vdd gnd OAI21X1
X_2172_ _3084_/S _2175_/A _2195_/C _2173_/B vdd gnd AOI21X1
XFILL_0__1894_ vdd gnd FILL
XFILL_0__3702_ vdd gnd FILL
X_2241_ _3987_/Q _3448_/B _2242_/B vdd gnd NAND2X1
XFILL_0__3633_ vdd gnd FILL
X_1956_ _1956_/A _1956_/B _2193_/B _1957_/C vdd gnd OAI21X1
X_1887_ _3765_/Q _3180_/B _1887_/Y vdd gnd NOR2X1
X_2508_ _2520_/C _3071_/B vdd gnd INVX1
X_3626_ _3626_/A _3626_/B _3709_/B _3782_/D vdd gnd MUX2X1
X_3557_ _3559_/C _3609_/B _3609_/A _3609_/D _3916_/D vdd gnd OAI22X1
X_3488_ _3488_/A _3950_/Q _3488_/C _3489_/B vdd gnd OAI21X1
X_2439_ _3967_/Q _2918_/S _3142_/A _2440_/A vdd gnd AOI21X1
X_2790_ _2790_/A _2917_/B _3921_/D vdd gnd AND2X2
XFILL_0_CLKBUF1_insert180 vdd gnd FILL
XFILL_0__2093_ vdd gnd FILL
XFILL_0__2162_ vdd gnd FILL
X_3342_ _4033_/Q _3345_/A vdd gnd INVX1
X_3411_ _3985_/Q _3443_/A _3421_/C vdd gnd NOR2X1
X_2155_ _3741_/Q _3142_/A vdd gnd INVX2
X_2224_ _3853_/Y _3302_/B _2227_/A vdd gnd NAND2X1
XFILL_0__3616_ vdd gnd FILL
X_3273_ _3906_/Q _3647_/A vdd gnd INVX1
X_2086_ _2086_/A _2134_/B _4061_/D vdd gnd AND2X2
XFILL_0__3547_ vdd gnd FILL
XFILL_0__3478_ vdd gnd FILL
XFILL_0__2429_ vdd gnd FILL
X_2988_ _3253_/C _2988_/B _3013_/C _3817_/D vdd gnd AOI21X1
X_3609_ _3609_/A _3609_/B _3614_/A _3609_/D _3804_/D vdd gnd OAI22X1
X_1939_ _2198_/C _1939_/B _1939_/C _1940_/B vdd gnd OAI21X1
XFILL_0_BUFX2_insert60 vdd gnd FILL
XFILL_0__3401_ vdd gnd FILL
X_2911_ _3860_/Q _2912_/A _2912_/C vdd gnd NAND2X1
X_3891_ _3891_/D _3917_/CLK _3891_/Q vdd gnd DFFPOSX1
X_3960_ _3960_/D _3980_/CLK _3960_/Q vdd gnd DFFPOSX1
XFILL_0__3332_ vdd gnd FILL
X_2773_ _2773_/A _2773_/B _2773_/C _2774_/A vdd gnd OAI21X1
X_2842_ _3893_/Q _3891_/Q _2918_/S _2844_/B vdd gnd MUX2X1
XFILL_0__2978_ vdd gnd FILL
X_3256_ _3256_/A _3311_/A _3256_/C _3256_/D _4082_/D vdd gnd AOI22X1
X_3325_ _3325_/A _3327_/A _3351_/S _4051_/D vdd gnd MUX2X1
XFILL_0__1929_ vdd gnd FILL
X_2207_ _3769_/Q _2371_/B vdd gnd INVX1
X_3187_ _3724_/Q _3193_/A vdd gnd INVX1
X_2069_ _3634_/B _2085_/B _2069_/C _2070_/A vdd gnd OAI21X1
X_2138_ _3993_/Q _3800_/Q _2146_/S _2139_/B vdd gnd MUX2X1
XFILL128550x108150 vdd gnd FILL
XFILL_0__2832_ vdd gnd FILL
XFILL_0__2901_ vdd gnd FILL
X_3110_ _3110_/A _3110_/B _3110_/C _3110_/D _3621_/B vdd gnd AOI22X1
X_3041_ _3791_/Q _3064_/B _3042_/B vdd gnd NAND2X1
X_4090_ _4090_/D _4090_/CLK _4090_/Q vdd gnd DFFPOSX1
X_3943_ _3943_/D _3943_/CLK _3943_/Q vdd gnd DFFPOSX1
X_2825_ _2825_/A _3845_/A _3905_/D vdd gnd AND2X2
XFILL_0__3177_ vdd gnd FILL
XFILL_0__3246_ vdd gnd FILL
XFILL_0__3315_ vdd gnd FILL
X_3874_ vdd _3906_/R _3874_/D _3997_/CLK _3874_/Q vdd gnd DFFSR
X_2756_ _3937_/Q _2773_/A _2757_/C vdd gnd NAND2X1
X_2687_ _2767_/S _2691_/A _2689_/A vdd gnd NAND2X1
XFILL_0__2128_ vdd gnd FILL
X_3308_ _3308_/A _3308_/B _3308_/C _4064_/D vdd gnd OAI21X1
X_3239_ _3308_/B _3239_/B _3239_/C _4090_/D vdd gnd AOI21X1
XFILL129150x111750 vdd gnd FILL
XFILL_0__3031_ vdd gnd FILL
XFILL_0__3100_ vdd gnd FILL
X_2541_ _2541_/A _4023_/D vdd gnd INVX1
X_2610_ _3051_/A _2610_/B _2610_/C _2633_/B vdd gnd NAND3X1
X_3590_ _3847_/Q _3593_/C vdd gnd INVX1
X_2472_ _3477_/A _2472_/B _2472_/C _2478_/A vdd gnd OAI21X1
XFILL_0__2746_ vdd gnd FILL
X_4073_ _4073_/D _4073_/CLK _4073_/Q vdd gnd DFFPOSX1
X_3024_ _3024_/A _3024_/B _3029_/B vdd gnd NOR2X1
XFILL_0__2677_ vdd gnd FILL
X_2808_ _2808_/A _2808_/B _3118_/C _3913_/D vdd gnd AOI21X1
X_3788_ _3788_/D _3885_/CLK _3788_/Q vdd gnd DFFPOSX1
X_3857_ _3862_/Y _3857_/Y vdd gnd INVX1
X_3926_ _3926_/D _4035_/CLK _3926_/Q vdd gnd DFFPOSX1
X_2739_ _3943_/Q _3941_/Q _2751_/S _2741_/B vdd gnd MUX2X1
XFILL129150x54150 vdd gnd FILL
XBUFX2_insert73 _3979_/Q _2890_/S vdd gnd BUFX2
XBUFX2_insert62 _3730_/Q _3540_/A vdd gnd BUFX2
XBUFX2_insert95 _1917_/Y _2191_/S vdd gnd BUFX2
XBUFX2_insert84 _1887_/Y _1938_/B vdd gnd BUFX2
XBUFX2_insert40 _3624_/Y _3650_/S vdd gnd BUFX2
XFILL_0__2600_ vdd gnd FILL
XFILL_0__3580_ vdd gnd FILL
XFILL_0__2531_ vdd gnd FILL
XFILL_0__3014_ vdd gnd FILL
X_3711_ _3711_/A _3711_/B _3794_/D vdd gnd NOR2X1
X_1972_ _1972_/A _1972_/B _2053_/B _1973_/C vdd gnd OAI21X1
X_3642_ _3642_/A _3642_/B _3646_/S _3736_/D vdd gnd MUX2X1
X_2524_ _3072_/A _2524_/B _2525_/A vdd gnd NOR2X1
X_2455_ _2457_/B _3619_/B vdd gnd INVX1
X_3573_ _3575_/C _3585_/B _3573_/C _3609_/D _3884_/D vdd gnd OAI22X1
X_2386_ _3842_/Q _3844_/Q _2388_/A vdd gnd NOR2X1
X_4056_ _4056_/D _4058_/CLK _4056_/Q vdd gnd DFFPOSX1
X_3007_ _3007_/A _3262_/B _3196_/C vdd gnd NAND2X1
X_3909_ _3909_/D _3979_/CLK _3909_/Q vdd gnd DFFPOSX1
XFILL_0__1962_ vdd gnd FILL
XFILL_0__3563_ vdd gnd FILL
X_2171_ _4040_/Q _2175_/A vdd gnd INVX1
X_2240_ _3412_/B _3413_/B _3448_/B vdd gnd NAND2X1
XFILL_0__2445_ vdd gnd FILL
XFILL_0__2376_ vdd gnd FILL
XFILL_0__3494_ vdd gnd FILL
X_1955_ _2083_/A _1955_/B _1956_/B vdd gnd NOR2X1
X_1886_ _4032_/Q _3180_/B vdd gnd INVX2
X_3625_ _3625_/A _3625_/B _3650_/S _3784_/D vdd gnd MUX2X1
X_2507_ _2507_/A _2507_/B _2520_/C vdd gnd NAND2X1
X_2438_ _2451_/A _2934_/B _3384_/C vdd gnd NOR2X1
X_3487_ _3488_/A _3642_/B _3488_/C vdd gnd NAND2X1
X_3556_ _3556_/A _3556_/Y vdd gnd INVX8
X_2369_ _2369_/A _3070_/B _4028_/D vdd gnd NOR2X1
X_4039_ _4039_/D _4049_/CLK _4039_/Q vdd gnd DFFPOSX1
XFILL_0__2230_ vdd gnd FILL
XFILL_0__2994_ vdd gnd FILL
X_3272_ _3316_/A _3275_/A _3272_/C _4076_/D vdd gnd AOI21X1
X_3341_ _3341_/A _3343_/A _3349_/S _4035_/D vdd gnd MUX2X1
XFILL_0__1945_ vdd gnd FILL
X_3410_ _3553_/B _3410_/B _3410_/C _3987_/D vdd gnd OAI21X1
X_2223_ _3738_/Q _3302_/B vdd gnd INVX2
XFILL_0__1876_ vdd gnd FILL
X_2085_ _3632_/B _2085_/B _2085_/C _2086_/A vdd gnd OAI21X1
X_2154_ _3712_/B _2175_/B _2154_/C _2160_/A vdd gnd OAI21X1
XFILL_0__2359_ vdd gnd FILL
X_2987_ _2987_/A _3262_/B _3253_/C vdd gnd NAND2X1
X_3608_ _3830_/Q _3614_/A vdd gnd INVX1
X_1869_ _1896_/A _3661_/Y _1876_/B vdd gnd NAND2X1
X_1938_ _4099_/Q _1938_/B _3082_/S _1939_/C vdd gnd NAND3X1
X_3539_ _3552_/A _3655_/B _3540_/C vdd gnd NAND2X1
XFILL_0_BUFX2_insert72 vdd gnd FILL
XFILL_0_BUFX2_insert83 vdd gnd FILL
XFILL_0_BUFX2_insert94 vdd gnd FILL
X_2910_ _3858_/Q _3856_/Q _2918_/S _2912_/B vdd gnd MUX2X1
X_2841_ _2841_/A _3845_/A _3897_/D vdd gnd AND2X2
XFILL_0__3193_ vdd gnd FILL
XFILL_0__3262_ vdd gnd FILL
X_3890_ vdd _3906_/R _3890_/D _3940_/CLK _3890_/Q vdd gnd DFFSR
X_2772_ _3929_/Q _2773_/A _2773_/C vdd gnd NAND2X1
XFILL_0__2075_ vdd gnd FILL
XFILL_0__2144_ vdd gnd FILL
X_3255_ _4084_/Q _3257_/B _3281_/C _3256_/D vdd gnd OAI21X1
X_3324_ _4051_/Q _3327_/A vdd gnd INVX1
X_2206_ _3180_/B _2206_/B _2206_/C _4032_/D vdd gnd AOI21X1
X_3186_ _3306_/A _3689_/A _3186_/C _3726_/D vdd gnd OAI21X1
X_2068_ _2068_/A _2068_/B _2133_/B _2069_/C vdd gnd OAI21X1
XFILL_0__3529_ vdd gnd FILL
X_2137_ _2169_/A _2137_/B _2140_/A vdd gnd NOR2X1
XFILL_0__2693_ vdd gnd FILL
X_3040_ _3070_/B _3040_/B _3063_/C _3042_/A vdd gnd NAND3X1
X_2824_ _2939_/A _2824_/B _2824_/C _2825_/A vdd gnd OAI21X1
X_3873_ _3873_/D _3893_/CLK _3873_/Q vdd gnd DFFPOSX1
X_3942_ _3942_/D _3985_/CLK _3942_/Q vdd gnd DFFPOSX1
X_2686_ _3971_/Q _2690_/B _2689_/B vdd gnd NAND2X1
X_2755_ _3935_/Q _3933_/Q _2767_/S _2757_/B vdd gnd MUX2X1
XFILL_0__2058_ vdd gnd FILL
X_3307_ _3307_/A _3308_/B _3308_/C vdd gnd NAND2X1
X_3169_ _3898_/Q _3649_/A vdd gnd INVX1
X_3238_ _4090_/Q _3308_/B _3239_/C vdd gnd NOR2X1
XFILL128850x10950 vdd gnd FILL
XFILL128850x100950 vdd gnd FILL
X_2540_ _2540_/A _2540_/B _2541_/A vdd gnd OR2X2
X_2471_ _3938_/Q _3997_/Q _3393_/B _2472_/C vdd gnd NAND3X1
X_3023_ _3023_/A _3024_/B _3023_/C _3026_/A vdd gnd OAI21X1
XFILL_0__2814_ vdd gnd FILL
X_4072_ _4072_/D _4072_/CLK _4072_/Q vdd gnd DFFPOSX1
X_3925_ _3925_/D _3943_/CLK _3925_/Q vdd gnd DFFPOSX1
X_2738_ _2738_/A _2782_/B _3947_/D vdd gnd AND2X2
X_2807_ _3913_/Q _2815_/A _2808_/A vdd gnd NAND2X1
X_3787_ _3787_/D _3837_/CLK _3787_/Q vdd gnd DFFPOSX1
X_3856_ _3856_/D _3917_/CLK _3856_/Q vdd gnd DFFPOSX1
XFILL_0__3228_ vdd gnd FILL
X_2669_ _2813_/S _3982_/Q _2952_/C _2670_/C vdd gnd OAI21X1
XBUFX2_insert74 _3979_/Q _2906_/S vdd gnd BUFX2
XBUFX2_insert30 i_rst_n _2913_/B vdd gnd BUFX2
XFILL128550x57750 vdd gnd FILL
XBUFX2_insert85 _1887_/Y _2083_/A vdd gnd BUFX2
XBUFX2_insert63 _1904_/Y _2122_/S vdd gnd BUFX2
XBUFX2_insert96 _1917_/Y _3082_/S vdd gnd BUFX2
XBUFX2_insert41 _3798_/Q _3624_/A vdd gnd BUFX2
XFILL_0__2392_ vdd gnd FILL
X_3710_ _3794_/Q _3710_/B _3711_/B vdd gnd NOR2X1
X_3572_ _3884_/Q _3575_/C vdd gnd INVX1
X_1971_ _2131_/A _1971_/B _1972_/B vdd gnd NOR2X1
X_3641_ _3641_/A _3641_/B _3712_/S _3744_/D vdd gnd MUX2X1
X_2523_ _3048_/B _3069_/B _2523_/C _2524_/B vdd gnd AOI21X1
X_2385_ _3976_/Q _2675_/C vdd gnd INVX1
X_2454_ _3853_/Y _2454_/B _2457_/B vdd gnd NAND2X1
XFILL_0__2728_ vdd gnd FILL
X_3006_ _3638_/A _3638_/B _3708_/A _3007_/A vdd gnd MUX2X1
X_4055_ _4055_/D _4073_/CLK _4055_/Q vdd gnd DFFPOSX1
X_3908_ _3908_/D _3916_/CLK _3908_/Q vdd gnd DFFPOSX1
X_3839_ _3839_/D _3900_/CLK _3839_/Q vdd gnd DFFPOSX1
XFILL128550x32550 vdd gnd FILL
XFILL_0__3700_ vdd gnd FILL
XFILL_0__1892_ vdd gnd FILL
XFILL_0__2513_ vdd gnd FILL
X_2170_ _2170_/A _2170_/B _2193_/B _2173_/A vdd gnd OAI21X1
XFILL_0__3631_ vdd gnd FILL
X_1954_ _4010_/Q _3839_/Q _2130_/S _1955_/B vdd gnd MUX2X1
X_3555_ _3804_/Q _3609_/A vdd gnd INVX1
X_1885_ _3721_/Q _2196_/A vdd gnd INVX1
X_3624_ _3624_/A _3708_/B _3735_/Q _3624_/Y vdd gnd OAI21X1
X_2368_ _2544_/C _2368_/B _2369_/A vdd gnd OR2X2
X_2506_ _3773_/Q _3775_/Q _3771_/Q _2507_/A vdd gnd OAI21X1
X_2437_ _2826_/S _2934_/B vdd gnd INVX2
X_3486_ _3948_/Q _3489_/A vdd gnd INVX1
X_2299_ _3832_/Q _2300_/B vdd gnd INVX1
X_4038_ _4038_/D _4093_/CLK _4038_/Q vdd gnd DFFPOSX1
XFILL_0_CLKBUF1_insert182 vdd gnd FILL
XFILL_0__2091_ vdd gnd FILL
X_3271_ _3276_/A _3271_/B _3271_/C _3272_/C vdd gnd OAI21X1
X_3340_ _4035_/Q _3343_/A vdd gnd INVX1
X_2222_ _3814_/A _2244_/A vdd gnd INVX1
X_2084_ _2084_/A _2084_/B _2085_/B _2085_/C vdd gnd OAI21X1
X_2153_ _2175_/B _3972_/Q _2169_/A _2154_/C vdd gnd AOI21X1
XFILL_0__3476_ vdd gnd FILL
XFILL_0__3545_ vdd gnd FILL
XFILL_0__2427_ vdd gnd FILL
X_1937_ _4006_/Q _3831_/Q _2082_/S _1939_/B vdd gnd MUX2X1
X_2986_ _3633_/A _3633_/B _3624_/A _2987_/A vdd gnd MUX2X1
X_1868_ _3729_/Q _1896_/A vdd gnd INVX1
X_3607_ _3607_/A _3611_/B _3607_/C _3611_/D _3808_/D vdd gnd OAI22X1
X_3538_ _3717_/Q _3655_/B vdd gnd INVX1
X_3469_ _3488_/A _3960_/Q _3469_/C _3470_/B vdd gnd OAI21X1
XFILL128550x111750 vdd gnd FILL
XFILL128250x54150 vdd gnd FILL
XFILL_0__3330_ vdd gnd FILL
XFILL_0__2212_ vdd gnd FILL
X_2771_ _3927_/Q _3925_/Q _2906_/S _2773_/B vdd gnd MUX2X1
X_2840_ _2926_/B _2840_/B _2840_/C _2841_/A vdd gnd OAI21X1
X_3254_ _4082_/Q _3256_/A vdd gnd INVX1
XFILL_0__2976_ vdd gnd FILL
X_3323_ _3323_/A _3325_/A _3349_/S _4054_/D vdd gnd MUX2X1
XFILL_0__1927_ vdd gnd FILL
X_2205_ _3702_/Y _3080_/B _3165_/C _2206_/C vdd gnd OAI21X1
X_3185_ _4046_/Q _3185_/B _3185_/C _3689_/A vdd gnd OAI21X1
X_2067_ _2177_/C _2067_/B _2068_/B vdd gnd NOR2X1
X_2136_ _4048_/Q _3968_/Q _2136_/S _2137_/B vdd gnd MUX2X1
X_2969_ _3826_/Q _3014_/B _3902_/R _2970_/C vdd gnd OAI21X1
XFILL129150x39750 vdd gnd FILL
XFILL129150x82950 vdd gnd FILL
XFILL_0__2761_ vdd gnd FILL
XFILL_0__2830_ vdd gnd FILL
X_3941_ _3941_/D _3955_/CLK _3941_/Q vdd gnd DFFPOSX1
X_2754_ _2754_/A _2782_/B _3939_/D vdd gnd AND2X2
X_2823_ _3905_/Q _2939_/A _2824_/C vdd gnd NAND2X1
XFILL_0__3244_ vdd gnd FILL
XFILL_0__2126_ vdd gnd FILL
X_3872_ _3872_/D _3916_/CLK _3872_/Q vdd gnd DFFPOSX1
XFILL_0__3175_ vdd gnd FILL
X_2685_ _2685_/A _2685_/B _2685_/C _3973_/D vdd gnd AOI21X1
X_3306_ _3306_/A _3689_/A _3306_/C _3307_/A vdd gnd OAI21X1
X_2119_ _4050_/Q _3627_/B vdd gnd INVX1
X_3168_ _3168_/A _3168_/B _3181_/C _3735_/D vdd gnd AOI21X1
X_3237_ _4092_/Q _3237_/B _3314_/S _3239_/B vdd gnd MUX2X1
X_3099_ _3117_/A _3117_/B _3845_/A _3120_/A vdd gnd OAI21X1
X_2470_ _3954_/Q _3477_/A vdd gnd INVX1
X_3022_ _3803_/Q _3023_/A vdd gnd INVX1
XFILL_0__2744_ vdd gnd FILL
XFILL_0__2675_ vdd gnd FILL
X_4071_ _4071_/D _4093_/CLK _4071_/Q vdd gnd DFFPOSX1
X_3924_ _3924_/D _3954_/CLK _3924_/Q vdd gnd DFFPOSX1
X_2737_ _2741_/A _2737_/B _2737_/C _2738_/A vdd gnd OAI21X1
X_2668_ _2668_/A _2690_/C _2670_/A vdd gnd NOR2X1
X_2806_ _2826_/S _2811_/B _2806_/C _2808_/B vdd gnd OAI21X1
XFILL_0__3089_ vdd gnd FILL
X_3855_ _3855_/D _4041_/CLK _3855_/Q vdd gnd DFFPOSX1
X_3786_ _3786_/D _3997_/CLK _3786_/Q vdd gnd DFFPOSX1
X_2599_ _3797_/Q _3799_/Q _2603_/B vdd gnd NOR2X1
XBUFX2_insert31 i_rst_n _2917_/B vdd gnd BUFX2
XBUFX2_insert20 _3556_/Y _3613_/D vdd gnd BUFX2
XBUFX2_insert42 _3798_/Q _3708_/A vdd gnd BUFX2
XBUFX2_insert75 _3979_/Q _2751_/S vdd gnd BUFX2
XBUFX2_insert86 _1887_/Y _2177_/C vdd gnd BUFX2
XBUFX2_insert97 _1917_/Y _2128_/S vdd gnd BUFX2
XBUFX2_insert64 _1904_/Y _2130_/S vdd gnd BUFX2
XFILL_0__2460_ vdd gnd FILL
X_1970_ _4017_/Q _3847_/Q _2130_/S _1971_/B vdd gnd MUX2X1
X_2522_ _2529_/B _3051_/A _2522_/C _2523_/C vdd gnd OAI21X1
X_3640_ _3640_/A _3640_/B _3650_/S _3746_/D vdd gnd MUX2X1
X_3571_ _3573_/C _3585_/B _3571_/C _3609_/D _3888_/D vdd gnd OAI22X1
X_2384_ _3698_/A _2390_/A _2393_/A vdd gnd NAND2X1
X_2453_ _3106_/A _2458_/A vdd gnd INVX1
XFILL_0__3845_ vdd gnd FILL
XFILL_0__2589_ vdd gnd FILL
X_3005_ _3751_/Q _3638_/A vdd gnd INVX1
X_4054_ _4054_/D _4058_/CLK _4054_/Q vdd gnd DFFPOSX1
X_3838_ _3838_/D _3840_/CLK _3838_/Q vdd gnd DFFPOSX1
X_3907_ _3907_/D _3907_/CLK _3907_/Q vdd gnd DFFPOSX1
X_3769_ _3769_/D _2373_/A _3769_/Q vdd gnd DFFPOSX1
XFILL_0__1960_ vdd gnd FILL
XFILL_0__2443_ vdd gnd FILL
XFILL_0__3492_ vdd gnd FILL
XFILL_0__2374_ vdd gnd FILL
X_1884_ _4016_/Q _3159_/B vdd gnd INVX1
X_1953_ _3083_/A _1953_/B _1956_/A vdd gnd NOR2X1
X_2505_ _2505_/A _2507_/B vdd gnd INVX1
X_3554_ _3916_/Q _3559_/C vdd gnd INVX1
X_3485_ _3485_/A _3485_/B _3531_/S _3950_/D vdd gnd MUX2X1
X_3623_ _3623_/A _3623_/B _3623_/C _3786_/D vdd gnd OAI21X1
X_2367_ _3999_/Q _2589_/A _3914_/R _2544_/C vdd gnd OAI21X1
X_2298_ _3787_/Q _2304_/C vdd gnd INVX1
X_2436_ _3907_/Q _2451_/A vdd gnd INVX1
X_4037_ _4037_/D _4049_/CLK _4037_/Q vdd gnd DFFPOSX1
X_3270_ _3270_/A _3275_/B _3276_/A _3271_/C vdd gnd NAND3X1
XFILL_0__1874_ vdd gnd FILL
XFILL_0__3613_ vdd gnd FILL
X_2152_ _2191_/S _2175_/B vdd gnd INVX1
X_2221_ _3743_/Q _3849_/Y _3412_/B vdd gnd NOR2X1
X_2083_ _2083_/A _2083_/B _2084_/B vdd gnd NOR2X1
XFILL_0__2288_ vdd gnd FILL
X_1867_ _3707_/A _1867_/B _3729_/D vdd gnd NOR2X1
X_1936_ _2195_/C _1936_/B _4099_/D vdd gnd NOR2X1
X_2985_ _3768_/Q _3633_/A vdd gnd INVX1
X_3468_ _3488_/A _3637_/B _3469_/C vdd gnd NAND2X1
X_3606_ _3607_/C _3611_/B _3606_/C _3611_/D _3812_/D vdd gnd OAI22X1
X_3537_ _3924_/Q _3541_/A vdd gnd INVX1
XFILL_0_BUFX2_insert74 vdd gnd FILL
X_2419_ _2419_/A _2419_/B _2419_/C _2441_/B vdd gnd AOI21X1
XFILL_0_BUFX2_insert63 vdd gnd FILL
X_3399_ _3754_/Q _3823_/Q _3401_/A vdd gnd NOR2X1
XFILL_0_BUFX2_insert41 vdd gnd FILL
XFILL_0_BUFX2_insert85 vdd gnd FILL
XFILL_0_BUFX2_insert96 vdd gnd FILL
X_2770_ _2770_/A _2782_/B _3931_/D vdd gnd AND2X2
XFILL_0__3191_ vdd gnd FILL
XFILL_0__2073_ vdd gnd FILL
XFILL_0__2142_ vdd gnd FILL
X_3322_ _4054_/Q _3325_/A vdd gnd INVX1
X_3253_ _3253_/A _3311_/A _3253_/C _3253_/D _4084_/D vdd gnd AOI22X1
XFILL129150x3750 vdd gnd FILL
X_2204_ _2204_/A _3080_/B vdd gnd INVX1
X_2135_ _4046_/Q _3625_/B vdd gnd INVX1
X_3184_ _3185_/B _3625_/A _3185_/C vdd gnd NAND2X1
XFILL_0__3527_ vdd gnd FILL
X_2066_ _4043_/Q _3896_/Q _2130_/S _2067_/B vdd gnd MUX2X1
XFILL_0__3458_ vdd gnd FILL
XFILL_0__2409_ vdd gnd FILL
X_2899_ _3867_/Q _2908_/A _2900_/C vdd gnd NAND2X1
X_2968_ _3817_/Q _3809_/Q _3805_/Q _2970_/B vdd gnd MUX2X1
X_1919_ _3607_/C _2192_/C _1919_/C _1920_/B vdd gnd OAI21X1
X_3871_ _3871_/D _3943_/CLK _3871_/Q vdd gnd DFFPOSX1
XFILL_0__3312_ vdd gnd FILL
X_3940_ _3940_/D _3940_/CLK _3940_/Q vdd gnd DFFPOSX1
X_2684_ _3973_/Q _3975_/Q _2952_/C _2685_/C vdd gnd OAI21X1
X_2753_ _2784_/B _2753_/B _2753_/C _2754_/A vdd gnd OAI21X1
X_2822_ _3903_/Q _3901_/Q _2826_/S _2824_/B vdd gnd MUX2X1
XFILL_0__2958_ vdd gnd FILL
X_3305_ _3305_/A _3305_/B _3305_/C _3306_/C vdd gnd OAI21X1
XFILL_0__1909_ vdd gnd FILL
X_3098_ _3098_/A _3098_/B _3098_/C _3755_/D vdd gnd AOI21X1
X_2049_ _2049_/A _2049_/B _2052_/A vdd gnd NOR2X1
X_2118_ _2118_/A _2134_/B _4052_/D vdd gnd AND2X2
X_3236_ _3629_/A _3629_/B _3313_/S _3237_/B vdd gnd MUX2X1
X_3167_ _3747_/Q _3666_/Y _3180_/A _3168_/A vdd gnd NAND3X1
XFILL_0__2812_ vdd gnd FILL
X_3021_ _3803_/Q _3021_/B _3021_/C _3803_/D vdd gnd AOI21X1
X_4070_ _4070_/D _4080_/CLK _4070_/Q vdd gnd DFFPOSX1
X_3923_ _3923_/D _3943_/CLK _3923_/Q vdd gnd DFFPOSX1
X_2805_ _2826_/S _2810_/A _2805_/C _2806_/C vdd gnd OAI21X1
X_3854_ _3854_/D _3907_/CLK _3854_/Q vdd gnd DFFPOSX1
XFILL_0__3226_ vdd gnd FILL
XFILL_0__3157_ vdd gnd FILL
X_2736_ _3947_/Q _2741_/A _2737_/C vdd gnd NAND2X1
X_2667_ _2667_/A _2667_/B _2667_/C _3981_/D vdd gnd AOI21X1
X_3785_ _3785_/D _3837_/CLK _3785_/Q vdd gnd DFFPOSX1
XFILL_0__2108_ vdd gnd FILL
X_2598_ _3805_/Q _3015_/C vdd gnd INVX1
X_3219_ _3626_/A _3626_/B _3708_/A _3222_/B vdd gnd MUX2X1
XBUFX2_insert10 _2275_/Y _3221_/A vdd gnd BUFX2
XBUFX2_insert65 _1904_/Y _2090_/S vdd gnd BUFX2
XBUFX2_insert21 _3556_/Y _3611_/D vdd gnd BUFX2
XBUFX2_insert43 _3798_/Q _3313_/S vdd gnd BUFX2
XBUFX2_insert32 i_rst_n _3910_/R vdd gnd BUFX2
XBUFX2_insert76 _3802_/Y _3118_/C vdd gnd BUFX2
XBUFX2_insert87 _1887_/Y _2123_/A vdd gnd BUFX2
XBUFX2_insert98 _1917_/Y _2187_/S vdd gnd BUFX2
XFILL_0__3011_ vdd gnd FILL
X_2521_ _3040_/B _2526_/A _2521_/C _2522_/C vdd gnd AOI21X1
X_3570_ _3888_/Q _3573_/C vdd gnd INVX1
XFILL_0__2726_ vdd gnd FILL
X_2452_ _2452_/A _3106_/C _3106_/A vdd gnd NAND2X1
X_2383_ _2461_/A _2454_/B _2493_/B _2390_/A vdd gnd NAND3X1
X_4053_ _4053_/D _4053_/CLK _4053_/Q vdd gnd DFFPOSX1
XFILL_0__2657_ vdd gnd FILL
X_3004_ _3009_/A _3004_/B _3809_/Q _3008_/B vdd gnd OAI21X1
X_3837_ _3837_/D _3837_/CLK _3837_/Q vdd gnd DFFPOSX1
X_3906_ _3906_/R vdd _3906_/D _3940_/CLK _3906_/Q vdd gnd DFFSR
X_3768_ _3910_/R vdd _3768_/D _4090_/CLK _3768_/Q vdd gnd DFFSR
X_2719_ _3953_/Q _3951_/Q _2751_/S _2721_/B vdd gnd MUX2X1
X_3699_ _3737_/Q _3700_/Y _3699_/Y vdd gnd NOR2X1
XFILL128250x39750 vdd gnd FILL
XFILL128250x82950 vdd gnd FILL
XFILL_0__3560_ vdd gnd FILL
XFILL_0__2511_ vdd gnd FILL
X_1883_ _3721_/Q _1883_/B _1883_/C _3721_/D vdd gnd AOI21X1
X_3622_ _3622_/A _3862_/Y _3622_/C _3788_/D vdd gnd OAI21X1
X_1952_ _4095_/Q _3924_/Q _2191_/S _1953_/B vdd gnd MUX2X1
X_2504_ _2504_/A _2504_/B _2590_/A _2511_/A vdd gnd NAND3X1
X_2435_ _2462_/A _2435_/B _3615_/A _3076_/A vdd gnd NAND3X1
X_3484_ _3525_/A _3952_/Q _3484_/C _3485_/B vdd gnd OAI21X1
X_3553_ _3553_/A _3553_/B _3553_/C _3553_/D _3918_/D vdd gnd AOI22X1
X_2366_ _3064_/B _2366_/B _3073_/A _4030_/D vdd gnd AOI21X1
X_2297_ _2297_/A _2359_/A vdd gnd INVX1
XFILL_0__3689_ vdd gnd FILL
X_4036_ _4036_/D _4099_/CLK _4036_/Q vdd gnd DFFPOSX1
XFILL128850x18150 vdd gnd FILL
XFILL128850x108150 vdd gnd FILL
XFILL_0_CLKBUF1_insert140 vdd gnd FILL
XFILL_0_CLKBUF1_insert151 vdd gnd FILL
XFILL_0_CLKBUF1_insert184 vdd gnd FILL
XFILL_0__2991_ vdd gnd FILL
XFILL_0__1942_ vdd gnd FILL
X_2220_ _3806_/Q _2289_/A vdd gnd INVX1
X_2082_ _4047_/Q _3904_/Q _2082_/S _2083_/B vdd gnd MUX2X1
X_2151_ _4042_/Q _2168_/A vdd gnd INVX1
XFILL_0__3543_ vdd gnd FILL
XFILL_0__2356_ vdd gnd FILL
X_2984_ _3221_/A _3004_/B _3817_/Q _2988_/B vdd gnd OAI21X1
XFILL_0__2425_ vdd gnd FILL
XFILL_0__3474_ vdd gnd FILL
X_1866_ _3729_/Q _3660_/Y _3658_/Y _1867_/B vdd gnd AOI21X1
X_1935_ _4099_/Q _1935_/B _3084_/S _1936_/B vdd gnd MUX2X1
X_3605_ _3606_/C _3611_/B _3605_/C _3611_/D _3816_/D vdd gnd OAI22X1
X_2418_ _3142_/A _2418_/B _3258_/A _2419_/B vdd gnd OAI21X1
X_3467_ _3958_/Q _3470_/A vdd gnd INVX1
X_3536_ _3536_/A _3536_/B _3545_/S _3926_/D vdd gnd MUX2X1
X_3398_ _3398_/A _3398_/B _3398_/C _3989_/D vdd gnd OAI21X1
X_2349_ _3781_/Q _2606_/A _2349_/C _2358_/A vdd gnd OAI21X1
X_4019_ _4019_/D _4047_/CLK _4019_/Q vdd gnd DFFPOSX1
XFILL_0__2210_ vdd gnd FILL
XFILL_0__2974_ vdd gnd FILL
X_3252_ _4086_/Q _3257_/B _3281_/C _3253_/D vdd gnd OAI21X1
X_3321_ _3321_/A _3323_/A _3351_/S _4056_/D vdd gnd MUX2X1
XFILL_0__1925_ vdd gnd FILL
X_2134_ _2134_/A _2134_/B _4048_/D vdd gnd AND2X2
X_2065_ _2081_/A _2065_/B _2068_/A vdd gnd NOR2X1
X_2203_ _3745_/Q _3701_/Y _2204_/A _2206_/B vdd gnd OAI21X1
X_3183_ _3784_/Q _3625_/A vdd gnd INVX1
XFILL_0__2339_ vdd gnd FILL
X_2967_ _3014_/B _2967_/B _2967_/C _2967_/D _3829_/D vdd gnd OAI22X1
XFILL_0__3388_ vdd gnd FILL
X_2898_ _3865_/Q _3863_/Q _2906_/S _2900_/B vdd gnd MUX2X1
X_1918_ _3719_/Q _1938_/B _3082_/S _1919_/C vdd gnd NAND3X1
X_3519_ _4097_/Q _3650_/B vdd gnd INVX1
XFILL_0__2690_ vdd gnd FILL
X_2821_ _2821_/A _3845_/A _3907_/D vdd gnd AND2X2
X_3870_ _3870_/A _3870_/B _3870_/Y vdd gnd NOR2X1
XFILL_0_BUFX2_insert1 vdd gnd FILL
XFILL_0__3173_ vdd gnd FILL
XFILL_0__3242_ vdd gnd FILL
X_2683_ _2683_/A _2683_/B _2813_/S _2685_/B vdd gnd OAI21X1
X_2752_ _3939_/Q _2784_/B _2753_/C vdd gnd NAND2X1
XFILL_0__2124_ vdd gnd FILL
XFILL_0__2055_ vdd gnd FILL
X_3304_ _3304_/A _3304_/B _3304_/C _3304_/D _3305_/C vdd gnd OAI22X1
X_3235_ _3776_/Q _3629_/A vdd gnd INVX1
X_3097_ _3098_/A _3098_/B _3845_/A _3098_/C vdd gnd OAI21X1
X_2117_ _3628_/B _2125_/B _2117_/C _2118_/A vdd gnd OAI21X1
X_2048_ _4071_/Q _3948_/Q _2064_/S _2049_/B vdd gnd MUX2X1
X_3166_ _3166_/A _3180_/A vdd gnd INVX1
XFILL_0__3509_ vdd gnd FILL
X_3999_ _3999_/D _4009_/CLK _3999_/Q vdd gnd DFFPOSX1
X_3020_ _3803_/Q _3021_/B _3031_/C _3021_/C vdd gnd OAI21X1
XFILL_0__2673_ vdd gnd FILL
XFILL_0_BUFX2_insert160 vdd gnd FILL
X_2804_ _3911_/Q _2826_/S _2805_/C vdd gnd NAND2X1
X_3853_ _3853_/A _3853_/Y vdd gnd INVX2
XFILL_0_BUFX2_insert171 vdd gnd FILL
X_3922_ _3922_/D _3954_/CLK _3922_/Q vdd gnd DFFPOSX1
X_3784_ _3906_/R vdd _3784_/D _3938_/CLK _3784_/Q vdd gnd DFFSR
X_2735_ _3945_/Q _3943_/Q _2751_/S _2737_/B vdd gnd MUX2X1
XFILL_0__3087_ vdd gnd FILL
X_2666_ _3981_/Q _2667_/B _3914_/R _2667_/C vdd gnd OAI21X1
X_2597_ _3014_/B _2597_/B _2597_/C _4003_/D vdd gnd AOI21X1
XFILL_0__2038_ vdd gnd FILL
X_3218_ _3782_/Q _3626_/A vdd gnd INVX1
X_3149_ _3279_/S _3652_/A _3150_/C vdd gnd NAND2X1
XBUFX2_insert11 _2275_/Y _2999_/A vdd gnd BUFX2
XBUFX2_insert77 _3802_/Y _3013_/C vdd gnd BUFX2
XBUFX2_insert99 _2577_/Y _3292_/A vdd gnd BUFX2
XBUFX2_insert22 _3556_/Y _3583_/D vdd gnd BUFX2
XBUFX2_insert66 _1904_/Y _2082_/S vdd gnd BUFX2
XBUFX2_insert33 i_rst_n _2189_/C vdd gnd BUFX2
XBUFX2_insert88 _1887_/Y _2198_/C vdd gnd BUFX2
XBUFX2_insert44 _3798_/Q _3694_/A vdd gnd BUFX2
XFILL128850x7350 vdd gnd FILL
X_2520_ _3043_/A _2537_/A _2520_/C _2521_/C vdd gnd OAI21X1
X_2451_ _2451_/A _2934_/B _2451_/C _2452_/A vdd gnd OAI21X1
X_3003_ _3199_/C _3003_/B _3003_/C _3811_/D vdd gnd AOI21X1
X_2382_ _3741_/Q _3726_/Q _2382_/C _2454_/B vdd gnd AOI21X1
X_4052_ _4052_/D _4073_/CLK _4052_/Q vdd gnd DFFPOSX1
X_3905_ _3905_/D _3907_/CLK _3905_/Q vdd gnd DFFPOSX1
X_2718_ _2718_/A _2913_/B _3957_/D vdd gnd AND2X2
X_3836_ _3836_/D _4009_/CLK _3836_/Q vdd gnd DFFPOSX1
XFILL_0__3208_ vdd gnd FILL
X_3767_ _3767_/D _3737_/D _3767_/Q vdd gnd DFFPOSX1
X_2649_ _3986_/Q _2668_/A vdd gnd INVX1
X_3698_ _3698_/A _3698_/B _3698_/C _3698_/D _3818_/D vdd gnd OAI22X1
XFILL129150x122550 vdd gnd FILL
XFILL_0__2372_ vdd gnd FILL
X_3621_ _3862_/Y _3621_/B _3622_/C vdd gnd NAND2X1
X_1951_ _4093_/Q _3648_/B vdd gnd INVX1
X_1882_ _3721_/Q _1883_/B _3669_/Y _1883_/C vdd gnd OAI21X1
X_3552_ _3552_/A _4044_/Q _3553_/B _3553_/C vdd gnd AOI21X1
X_2365_ _2365_/A _3070_/B _4030_/Q _2366_/B vdd gnd OAI21X1
X_2503_ _2671_/B _2503_/B _2503_/C _2504_/B vdd gnd OAI21X1
X_2434_ _2434_/A _2434_/B _2434_/C _2435_/B vdd gnd NAND3X1
X_3483_ _3525_/A _3641_/B _3484_/C vdd gnd NAND2X1
XFILL_0__2708_ vdd gnd FILL
X_2296_ _2296_/A _2296_/B _2296_/C _2297_/A vdd gnd NAND3X1
X_4035_ _4035_/D _4035_/CLK _4035_/Q vdd gnd DFFPOSX1
X_3819_ _3819_/D _4076_/CLK _3819_/Q vdd gnd DFFPOSX1
XFILL_0__1872_ vdd gnd FILL
X_2081_ _2081_/A _2081_/B _2084_/A vdd gnd NOR2X1
X_2150_ _2150_/A _2189_/C _4044_/D vdd gnd AND2X2
XFILL_0__3611_ vdd gnd FILL
X_2983_ _3256_/C _2983_/B _3013_/C _3819_/D vdd gnd AOI21X1
X_1934_ _1938_/B _1934_/B _1934_/C _1935_/B vdd gnd OAI21X1
X_1865_ _3163_/Y o_mem_mosi vdd gnd BUFX2
X_3535_ _3540_/A _3928_/Q _3535_/C _3536_/B vdd gnd OAI21X1
X_3604_ _3816_/Q _3606_/C vdd gnd INVX1
X_2348_ _2348_/A _2348_/B _2349_/C vdd gnd NOR2X1
X_2417_ _4080_/Q _3258_/A vdd gnd INVX1
X_3466_ _3466_/A _3466_/B _3470_/S _3960_/D vdd gnd MUX2X1
X_3397_ _3989_/Q _3398_/A _3398_/C vdd gnd NAND2X1
X_2279_ _2290_/A _2590_/A _2280_/C vdd gnd NAND2X1
XFILL_0_BUFX2_insert10 vdd gnd FILL
XFILL_0_BUFX2_insert76 vdd gnd FILL
X_4018_ _4018_/D _3162_/A _4018_/Q vdd gnd DFFPOSX1
XFILL_0_BUFX2_insert87 vdd gnd FILL
XFILL_0_BUFX2_insert98 vdd gnd FILL
XFILL_0_BUFX2_insert65 vdd gnd FILL
XFILL_0_BUFX2_insert21 vdd gnd FILL
XFILL_0_BUFX2_insert43 vdd gnd FILL
XFILL_0_BUFX2_insert32 vdd gnd FILL
XFILL_0__2071_ vdd gnd FILL
X_3251_ _4084_/Q _3253_/A vdd gnd INVX1
X_3182_ _3305_/A _3305_/B _3726_/Q _3186_/C vdd gnd OAI21X1
X_3320_ _4056_/Q _3323_/A vdd gnd INVX1
X_2202_ _3166_/A _3667_/Y _2204_/A vdd gnd NOR2X1
X_2133_ _3626_/B _2133_/B _2133_/C _2134_/A vdd gnd OAI21X1
X_2064_ _4067_/Q _3952_/Q _2064_/S _2065_/B vdd gnd MUX2X1
XFILL_0__3456_ vdd gnd FILL
XFILL_0__3525_ vdd gnd FILL
X_2966_ _2966_/A _2966_/B _2966_/C _2967_/D vdd gnd OAI21X1
X_2897_ _2897_/A _2917_/B _3869_/D vdd gnd AND2X2
XFILL_0__2407_ vdd gnd FILL
X_1917_ _3761_/Q _1917_/B _1917_/Y vdd gnd NAND2X1
X_3518_ _3932_/Q _3522_/A vdd gnd INVX1
X_3449_ _3449_/A _4059_/Q _3551_/A _3450_/B vdd gnd MUX2X1
XFILL_0__3310_ vdd gnd FILL
X_2751_ _3937_/Q _3935_/Q _2751_/S _2753_/B vdd gnd MUX2X1
X_2820_ _2939_/A _2820_/B _2820_/C _2821_/A vdd gnd OAI21X1
X_2682_ _3973_/Q _2690_/B _2685_/A vdd gnd NAND2X1
XFILL_0__2956_ vdd gnd FILL
XFILL_0__2887_ vdd gnd FILL
X_3303_ _4098_/Q _3303_/B _3304_/B _3304_/C vdd gnd OAI21X1
X_3234_ _3308_/B _3234_/B _3234_/C _4092_/D vdd gnd AOI21X1
XFILL_0__1907_ vdd gnd FILL
X_3165_ _4032_/Q _3166_/A _3165_/C _3181_/C vdd gnd OAI21X1
X_3096_ _3096_/A _3096_/B _3096_/C _3756_/D vdd gnd AOI21X1
X_2047_ _4069_/Q _3636_/B vdd gnd INVX1
X_2116_ _2116_/A _2116_/B _2125_/B _2117_/C vdd gnd OAI21X1
XFILL_0__3439_ vdd gnd FILL
X_2949_ _3803_/Q _3014_/B _2950_/A vdd gnd NAND2X1
X_3998_ _3998_/D _4100_/CLK _3998_/Q vdd gnd DFFPOSX1
XFILL_0__2741_ vdd gnd FILL
XFILL_0__2810_ vdd gnd FILL
X_3921_ _3921_/D _3943_/CLK _3921_/Q vdd gnd DFFPOSX1
X_2734_ _2734_/A _2782_/B _3949_/D vdd gnd AND2X2
X_3783_ _3783_/D _4021_/CLK _3783_/Q vdd gnd DFFPOSX1
X_2803_ _3909_/Q _2810_/A vdd gnd INVX1
X_3852_ _3852_/D _4100_/CLK _3852_/Q vdd gnd DFFPOSX1
XFILL_0__3224_ vdd gnd FILL
XFILL_0__2106_ vdd gnd FILL
XFILL_0__3155_ vdd gnd FILL
X_2665_ _2665_/A _2665_/B _2667_/B vdd gnd NOR2X1
X_2596_ _4003_/Q _3014_/B _3902_/R _2597_/C vdd gnd OAI21X1
X_3217_ _3217_/A _3308_/B vdd gnd INVX4
X_3148_ _3886_/Q _3652_/A vdd gnd INVX1
X_3079_ _3611_/C _3611_/B _3079_/C _3079_/D _3767_/D vdd gnd OAI22X1
XBUFX2_insert78 _3802_/Y _3062_/C vdd gnd BUFX2
XBUFX2_insert34 i_rst_n _3902_/R vdd gnd BUFX2
XBUFX2_insert89 _2274_/Y _3004_/B vdd gnd BUFX2
XBUFX2_insert12 _2275_/Y _3305_/A vdd gnd BUFX2
XBUFX2_insert23 _3556_/Y _3614_/D vdd gnd BUFX2
XBUFX2_insert56 _3730_/Q _3548_/A vdd gnd BUFX2
XBUFX2_insert67 _1904_/Y _2146_/S vdd gnd BUFX2
XBUFX2_insert45 _3798_/Q _3279_/S vdd gnd BUFX2
XFILL128850x46950 vdd gnd FILL
X_2450_ _3792_/Q _2451_/C vdd gnd INVX1
X_2381_ _3138_/A _3134_/A _2382_/C vdd gnd NAND2X1
XFILL_0__2724_ vdd gnd FILL
XFILL_0__2655_ vdd gnd FILL
X_3002_ _3002_/A _3698_/B _3199_/C vdd gnd NAND2X1
X_4051_ _4051_/D _4058_/CLK _4051_/Q vdd gnd DFFPOSX1
XFILL_0__2586_ vdd gnd FILL
X_3904_ _3904_/D _3916_/CLK _3904_/Q vdd gnd DFFPOSX1
X_2717_ _2773_/A _2717_/B _2717_/C _2718_/A vdd gnd OAI21X1
XFILL_0__3069_ vdd gnd FILL
X_3697_ _3697_/A _3697_/B _3697_/C _3698_/C vdd gnd OAI21X1
XFILL_0__3138_ vdd gnd FILL
X_3835_ _3835_/D _4045_/CLK _3835_/Q vdd gnd DFFPOSX1
X_3766_ _3910_/R vdd _3766_/D _4092_/CLK _3766_/Q vdd gnd DFFSR
X_2648_ _3986_/Q _2690_/B _2659_/B vdd gnd NAND2X1
X_2579_ _3636_/A _3636_/B _3624_/A _3292_/B vdd gnd MUX2X1
XFILL128850x21750 vdd gnd FILL
XFILL128850x111750 vdd gnd FILL
XFILL_0__2440_ vdd gnd FILL
X_1950_ _1950_/A _3906_/R _4095_/D vdd gnd AND2X2
X_2502_ _2503_/B _3978_/Q _3773_/Q _2503_/C vdd gnd AOI21X1
X_3620_ _3788_/Q _3622_/A vdd gnd INVX1
X_1881_ _1881_/A _1881_/B _3668_/Y _3723_/D vdd gnd AOI21X1
X_3551_ _3551_/A _3551_/B _3553_/D vdd gnd NAND2X1
X_2364_ _2665_/A _3773_/Q _2365_/A vdd gnd OR2X2
X_2433_ _2433_/A _3615_/B _2434_/A vdd gnd NAND2X1
X_3482_ _3950_/Q _3485_/A vdd gnd INVX1
XFILL_0__2569_ vdd gnd FILL
X_2295_ _3779_/Q _2608_/A _2296_/C vdd gnd NAND2X1
X_4034_ _4034_/D _4099_/CLK _4034_/Q vdd gnd DFFPOSX1
X_3818_ _3902_/R vdd _3818_/D _4084_/CLK _3818_/Q vdd gnd DFFSR
X_3749_ _3902_/R vdd _3749_/D _4072_/CLK _3749_/Q vdd gnd DFFSR
XFILL_0_CLKBUF1_insert120 vdd gnd FILL
XFILL_0_CLKBUF1_insert153 vdd gnd FILL
XFILL_0_CLKBUF1_insert142 vdd gnd FILL
XFILL_0_CLKBUF1_insert131 vdd gnd FILL
XFILL_0__1940_ vdd gnd FILL
XFILL_0__2423_ vdd gnd FILL
XFILL_0__3472_ vdd gnd FILL
X_2080_ _4063_/Q _3956_/Q _2136_/S _2081_/B vdd gnd MUX2X1
XFILL_0__2354_ vdd gnd FILL
X_2982_ _2982_/A _3262_/B _3256_/C vdd gnd NAND2X1
X_1933_ _3713_/Q _1938_/B _3082_/S _1934_/C vdd gnd NAND3X1
XFILL_0__2285_ vdd gnd FILL
X_3465_ _3465_/A _3962_/Q _3465_/C _3466_/B vdd gnd OAI21X1
X_1864_ _3162_/Y o_mem_sck vdd gnd BUFX2
X_3534_ _3540_/A _3653_/B _3535_/C vdd gnd NAND2X1
X_3603_ _3605_/C _3611_/B _3603_/C _3611_/D _3820_/D vdd gnd OAI22X1
X_2347_ _2347_/A _2347_/B _2347_/C _2348_/B vdd gnd NAND3X1
X_2278_ _3999_/Q _3277_/B _2290_/A vdd gnd NOR2X1
X_2416_ _3282_/D _3741_/Q _2416_/C _2419_/A vdd gnd NAND3X1
X_3396_ _3403_/B _3396_/B _3396_/C _3398_/B vdd gnd AOI21X1
X_4017_ _4017_/D _4047_/CLK _4017_/Q vdd gnd DFFPOSX1
XFILL_0__2972_ vdd gnd FILL
X_3250_ _3250_/A _3311_/A _3250_/C _3250_/D _4086_/D vdd gnd AOI22X1
X_2132_ _2132_/A _2132_/B _2133_/B _2133_/C vdd gnd OAI21X1
X_2201_ _3080_/C _2549_/B _3166_/A vdd gnd NAND2X1
X_3181_ _3181_/A _3181_/B _3181_/C _3730_/D vdd gnd AOI21X1
X_2063_ _4065_/Q _3634_/B vdd gnd INVX1
X_2896_ _2896_/A _2896_/B _2896_/C _2897_/A vdd gnd OAI21X1
X_2965_ _3805_/Q _2965_/B _2965_/C _2966_/C vdd gnd AOI21X1
XFILL_0__2268_ vdd gnd FILL
X_1916_ _3812_/Q _3607_/C vdd gnd INVX1
XFILL_0__2199_ vdd gnd FILL
X_3448_ _3968_/Q _3448_/B _3448_/C _3449_/A vdd gnd OAI21X1
X_3517_ _3517_/A _3517_/B _3522_/S _3934_/D vdd gnd MUX2X1
X_3379_ _3379_/A _3398_/A _3379_/C _3993_/D vdd gnd AOI21X1
XFILL_0_BUFX2_insert3 vdd gnd FILL
X_2681_ _2681_/A _3975_/Q _2681_/C _3975_/D vdd gnd AOI21X1
X_2750_ _2750_/A _2782_/B _3941_/D vdd gnd AND2X2
XFILL_0__2053_ vdd gnd FILL
XFILL_0__2122_ vdd gnd FILL
XFILL_0__3171_ vdd gnd FILL
X_3302_ _3853_/A _3302_/B _3304_/B vdd gnd NAND2X1
X_3095_ _3096_/A _3096_/B _3845_/A _3096_/C vdd gnd OAI21X1
X_3233_ _4092_/Q _3308_/B _3234_/C vdd gnd NOR2X1
X_2115_ _2123_/A _2115_/B _2116_/B vdd gnd NOR2X1
X_3164_ _3735_/Q _3168_/B vdd gnd INVX1
X_2046_ _2046_/A _2189_/C _4071_/D vdd gnd AND2X2
XFILL_0__3507_ vdd gnd FILL
X_3997_ _3997_/D _3997_/CLK _3997_/Q vdd gnd DFFPOSX1
X_2948_ _4014_/Q _3015_/B _3840_/Q _2950_/B vdd gnd OAI21X1
X_2879_ _3877_/Q _2880_/A _2880_/C vdd gnd NAND2X1
XFILL128550x122550 vdd gnd FILL
XFILL_0__2671_ vdd gnd FILL
X_3851_ _3851_/D _4047_/CLK _3851_/Q vdd gnd DFFPOSX1
X_3920_ _3920_/D _3985_/CLK _3920_/Q vdd gnd DFFPOSX1
X_2733_ _2741_/A _2733_/B _2733_/C _2734_/A vdd gnd OAI21X1
XFILL_0_BUFX2_insert162 vdd gnd FILL
X_2802_ _2802_/A _2913_/B _3915_/D vdd gnd AND2X2
XFILL_0_BUFX2_insert173 vdd gnd FILL
X_2664_ _2664_/A _3982_/D vdd gnd INVX1
X_3782_ _3914_/R vdd _3782_/D _3700_/A _3782_/Q vdd gnd DFFSR
XFILL_0__2938_ vdd gnd FILL
X_2595_ _3990_/Q _4011_/Q _3805_/Q _2597_/B vdd gnd MUX2X1
X_3147_ _3849_/Y _3290_/B _3698_/D _3740_/D vdd gnd OAI21X1
X_3216_ _3216_/A _3216_/B _3862_/Y _3295_/A _3217_/A vdd gnd OAI22X1
X_3078_ _3752_/Q _3078_/B _3556_/A _3079_/C vdd gnd OAI21X1
XBUFX2_insert24 i_rst_n _3845_/A vdd gnd BUFX2
XBUFX2_insert13 _2275_/Y _3009_/A vdd gnd BUFX2
X_2029_ _3639_/B _2053_/B _2029_/C _2030_/A vdd gnd OAI21X1
XBUFX2_insert68 _3979_/Q _2826_/S vdd gnd BUFX2
XFILL129150x93750 vdd gnd FILL
XBUFX2_insert79 _3802_/Y _3707_/A vdd gnd BUFX2
XBUFX2_insert57 _3730_/Q _3488_/A vdd gnd BUFX2
XBUFX2_insert46 _3798_/Q _3185_/B vdd gnd BUFX2
XBUFX2_insert35 i_rst_n _3906_/R vdd gnd BUFX2
X_2380_ _3189_/A _3853_/Y _2493_/B vdd gnd AND2X2
X_3001_ _3639_/A _3639_/B _3624_/A _3002_/A vdd gnd MUX2X1
X_4050_ _4050_/D _4073_/CLK _4050_/Q vdd gnd DFFPOSX1
X_3834_ _3834_/D _3996_/CLK _3834_/Q vdd gnd DFFPOSX1
X_3903_ _3903_/D _3907_/CLK _3903_/Q vdd gnd DFFPOSX1
XFILL_0__3206_ vdd gnd FILL
X_2716_ _3957_/Q _2773_/A _2717_/C vdd gnd NAND2X1
X_2647_ _2813_/S _3982_/Q _2690_/B vdd gnd NOR2X1
XFILL129150x25350 vdd gnd FILL
X_3765_ _3765_/D _3162_/A _3765_/Q vdd gnd DFFPOSX1
X_3696_ _3696_/A _3697_/C vdd gnd INVX1
X_2578_ _3762_/Q _3636_/A vdd gnd INVX1
XFILL_0__2370_ vdd gnd FILL
X_1880_ _3723_/Q _3158_/B _1881_/B vdd gnd NAND2X1
X_2501_ _3069_/A _3069_/B _2504_/A vdd gnd NOR2X1
X_3481_ _3481_/A _3481_/B _3522_/S _3952_/D vdd gnd MUX2X1
X_3550_ _3918_/Q _3553_/A vdd gnd INVX1
X_2363_ _2363_/A _2363_/B _2665_/A vdd gnd NAND2X1
XFILL_0__2706_ vdd gnd FILL
X_2294_ _3999_/Q _4003_/Q _2590_/A _2294_/D _2608_/A vdd gnd AOI22X1
X_2432_ _3870_/A _3373_/C _2462_/A vdd gnd NAND2X1
X_4033_ _4033_/D _4058_/CLK _4033_/Q vdd gnd DFFPOSX1
XFILL_0__2637_ vdd gnd FILL
XFILL_0__3686_ vdd gnd FILL
X_3817_ _3817_/D _4076_/CLK _3817_/Q vdd gnd DFFPOSX1
X_3748_ _3748_/D _4053_/CLK _3810_/A vdd gnd DFFPOSX1
X_3679_ _3833_/Q _3828_/Q _3680_/A vdd gnd NOR2X1
XFILL_0__3540_ vdd gnd FILL
X_1863_ _4018_/Q o_mem_sync vdd gnd BUFX2
X_1932_ _4004_/Q _3825_/Q _2146_/S _1934_/B vdd gnd MUX2X1
X_3602_ _3820_/Q _3605_/C vdd gnd INVX1
X_2981_ _3634_/A _3634_/B _3708_/A _2982_/A vdd gnd MUX2X1
X_2415_ _2494_/A _2426_/A vdd gnd INVX1
X_3464_ _3465_/A _3636_/B _3465_/C vdd gnd NAND2X1
X_3533_ _3715_/Q _3653_/B vdd gnd INVX1
X_2346_ _2346_/A _2346_/B _3033_/B _2346_/D _2347_/B vdd gnd AOI22X1
X_4016_ _4016_/D _4016_/CLK _4016_/Q vdd gnd DFFPOSX1
XFILL_0_BUFX2_insert34 vdd gnd FILL
X_2277_ _3009_/A _3004_/B _2352_/B _2590_/A vdd gnd OAI21X1
XFILL_0_BUFX2_insert12 vdd gnd FILL
XFILL_0_BUFX2_insert23 vdd gnd FILL
XFILL_0__3669_ vdd gnd FILL
XFILL_0_BUFX2_insert56 vdd gnd FILL
X_3395_ _3726_/Q _3989_/Q _3396_/B vdd gnd AND2X2
XFILL_0_BUFX2_insert45 vdd gnd FILL
XFILL_0_BUFX2_insert78 vdd gnd FILL
XFILL_0_BUFX2_insert89 vdd gnd FILL
XFILL_0_BUFX2_insert67 vdd gnd FILL
XFILL_0__1922_ vdd gnd FILL
X_2131_ _2131_/A _2131_/B _2132_/B vdd gnd NOR2X1
X_2062_ _2062_/A _2134_/B _4067_/D vdd gnd AND2X2
XFILL_0__3523_ vdd gnd FILL
X_2200_ _3700_/Y _3737_/Q _2200_/C _3080_/C vdd gnd OAI21X1
X_3180_ _3180_/A _3180_/B _3552_/A _3181_/A vdd gnd AOI21X1
XFILL_0__2336_ vdd gnd FILL
X_2964_ _3805_/Q _3811_/Q _2965_/C vdd gnd NOR2X1
XFILL_0__2405_ vdd gnd FILL
XFILL_0__3385_ vdd gnd FILL
XFILL_0__3454_ vdd gnd FILL
X_2895_ _3869_/Q _2896_/A _2896_/C vdd gnd NAND2X1
X_1915_ _2195_/C _1915_/B _3719_/D vdd gnd NOR2X1
X_3447_ _3970_/Q _3448_/B _3448_/C vdd gnd NAND2X1
X_3516_ _3540_/A _3936_/Q _3516_/C _3517_/B vdd gnd OAI21X1
X_3378_ _3989_/Q _3398_/A _3379_/C vdd gnd NOR2X1
X_2329_ _2529_/A _3840_/Q _2330_/C vdd gnd OR2X2
X_2680_ _3975_/Q _2813_/S _2952_/C _2681_/C vdd gnd OAI21X1
XFILL_0__2954_ vdd gnd FILL
XFILL_0__2885_ vdd gnd FILL
X_3301_ _4070_/Q _3301_/B _3301_/C _3304_/D vdd gnd AOI21X1
X_3232_ _4094_/Q _3232_/B _3314_/S _3234_/B vdd gnd MUX2X1
XFILL_0__1905_ vdd gnd FILL
X_3094_ _3412_/C _3096_/B vdd gnd INVX1
X_3163_ _3763_/Q _4018_/Q _3163_/Y vdd gnd AND2X2
X_2114_ _4056_/Q _3804_/Q _2122_/S _2115_/B vdd gnd MUX2X1
X_2045_ _3637_/B _2045_/B _2045_/C _2046_/A vdd gnd OAI21X1
X_2947_ _2947_/A _2947_/B _2947_/C _3842_/D vdd gnd AOI21X1
X_3996_ _3996_/D _3996_/CLK _3996_/Q vdd gnd DFFPOSX1
XFILL_0__2319_ vdd gnd FILL
XFILL_0__3299_ vdd gnd FILL
XFILL_0__3368_ vdd gnd FILL
X_2878_ _3875_/Q _3873_/Q _2890_/S _2880_/B vdd gnd MUX2X1
X_3781_ _3781_/D _4021_/CLK _3781_/Q vdd gnd DFFPOSX1
X_2801_ _2801_/A _2801_/B _2801_/C _2802_/A vdd gnd OAI21X1
X_3850_ _3850_/D _4100_/CLK _3850_/Q vdd gnd DFFPOSX1
XFILL_0__3222_ vdd gnd FILL
XFILL_0__3153_ vdd gnd FILL
X_2732_ _3949_/Q _2741_/A _2733_/C vdd gnd NAND2X1
X_2663_ _2952_/C _4014_/Q _4012_/Q _2664_/A vdd gnd NAND3X1
X_2594_ _2594_/A _2594_/B _2943_/C _4005_/D vdd gnd AOI21X1
XFILL_0__2035_ vdd gnd FILL
XFILL_0__2104_ vdd gnd FILL
XFILL_0__3084_ vdd gnd FILL
XFILL_0__2868_ vdd gnd FILL
X_3215_ _3849_/Y _3215_/B _3216_/A vdd gnd NAND2X1
XFILL_0__2799_ vdd gnd FILL
X_3146_ _3146_/A _3698_/B _3698_/D vdd gnd NAND2X1
X_3077_ _3118_/C _3617_/C _3556_/A vdd gnd NOR2X1
X_2028_ _2028_/A _2028_/B _2053_/B _2029_/C vdd gnd OAI21X1
X_3979_ _3979_/D _3979_/CLK _3979_/Q vdd gnd DFFPOSX1
XBUFX2_insert25 i_rst_n _3914_/R vdd gnd BUFX2
XBUFX2_insert14 _3075_/Y _3613_/B vdd gnd BUFX2
XBUFX2_insert36 _3624_/Y _3709_/B vdd gnd BUFX2
XBUFX2_insert69 _3979_/Q _2918_/S vdd gnd BUFX2
XBUFX2_insert58 _3730_/Q _3525_/A vdd gnd BUFX2
XFILL_0__2653_ vdd gnd FILL
XFILL_0__2584_ vdd gnd FILL
X_3000_ _3749_/Q _3639_/A vdd gnd INVX1
X_3833_ _3833_/D _3837_/CLK _3833_/Q vdd gnd DFFPOSX1
X_3764_ _3914_/R vdd _3764_/D _4072_/CLK _3764_/Q vdd gnd DFFSR
X_3902_ _3902_/R vdd _3902_/D _3938_/CLK _3902_/Q vdd gnd DFFSR
X_2715_ _3955_/Q _3953_/Q _2751_/S _2717_/B vdd gnd MUX2X1
X_2646_ _3706_/B _2646_/B _3003_/C _3988_/D vdd gnd AOI21X1
XFILL_0__3067_ vdd gnd FILL
X_2577_ _3306_/A _2577_/Y vdd gnd INVX8
XFILL_0__2018_ vdd gnd FILL
X_3695_ _3695_/A _3695_/B _3695_/C _3696_/A vdd gnd NAND3X1
X_3129_ _3129_/A _3129_/B _3129_/C _3745_/D vdd gnd AOI21X1
XFILL128550x28950 vdd gnd FILL
X_2500_ _2500_/A _3067_/B _3069_/B vdd gnd NOR2X1
X_2431_ _3755_/Q _3403_/A _3373_/C vdd gnd NOR2X1
X_3480_ _3521_/A _3954_/Q _3480_/C _3481_/B vdd gnd OAI21X1
X_2362_ _3769_/Q _3771_/Q _2363_/B vdd gnd NOR2X1
X_2293_ _3999_/Q _3265_/A _2294_/D vdd gnd NOR2X1
X_4032_ _4032_/D _3162_/A _4032_/Q vdd gnd DFFPOSX1
XFILL_0__2567_ vdd gnd FILL
XFILL_0__2498_ vdd gnd FILL
X_3816_ _3816_/D _4008_/CLK _3816_/Q vdd gnd DFFPOSX1
X_3747_ _3747_/D _3162_/A _3747_/Q vdd gnd DFFPOSX1
X_2629_ _2947_/A _2947_/B _2631_/B vdd gnd NOR2X1
X_3678_ _3678_/A _3710_/B _3837_/D vdd gnd NOR2X1
XFILL_0_CLKBUF1_insert122 vdd gnd FILL
XFILL_0_CLKBUF1_insert133 vdd gnd FILL
XFILL_0__2352_ vdd gnd FILL
XFILL_0__3470_ vdd gnd FILL
X_2980_ _3766_/Q _3634_/A vdd gnd INVX1
X_1862_ _2535_/Y o_rf_mosi vdd gnd BUFX2
X_3601_ _3603_/C _3613_/B _3601_/C _3611_/D _3825_/D vdd gnd OAI22X1
X_1931_ _2195_/C _1931_/B _3713_/D vdd gnd NOR2X1
XFILL_0__2283_ vdd gnd FILL
X_2414_ _3997_/Q _2494_/A _3372_/A _2434_/C vdd gnd NAND3X1
X_3463_ _3960_/Q _3466_/A vdd gnd INVX1
X_3532_ _3926_/Q _3536_/A vdd gnd INVX1
X_3394_ _3394_/A _3394_/B _3398_/A _3991_/D vdd gnd AOI21X1
X_2345_ _4020_/Q _2589_/A _2346_/B vdd gnd NAND2X1
X_2276_ _3706_/B _3977_/Q _2352_/B vdd gnd AND2X2
X_4015_ _4015_/D _3685_/A _4015_/Q vdd gnd DFFPOSX1
XFILL_0__1998_ vdd gnd FILL
XFILL128250x93750 vdd gnd FILL
X_2130_ _3995_/Q _3796_/Q _2130_/S _2131_/B vdd gnd MUX2X1
X_2061_ _3635_/B _2133_/B _2061_/C _2062_/A vdd gnd OAI21X1
X_2963_ _3819_/Q _2965_/B vdd gnd INVX1
XFILL_0__2266_ vdd gnd FILL
X_1914_ _3719_/Q _1914_/B _3084_/S _1915_/B vdd gnd MUX2X1
X_2894_ _3867_/Q _3865_/Q _2906_/S _2896_/B vdd gnd MUX2X1
XFILL_0__2197_ vdd gnd FILL
X_3515_ _3540_/A _3649_/B _3516_/C vdd gnd NAND2X1
X_2328_ _2328_/A _2328_/B _2328_/C _2348_/A vdd gnd NAND3X1
X_3377_ _3379_/A _3377_/B _3377_/S _3995_/D vdd gnd MUX2X1
X_3446_ _3968_/Q _3553_/B _3450_/C vdd gnd NAND2X1
X_2259_ _2259_/A _2259_/B _2287_/A _3706_/B vdd gnd AOI21X1
XFILL128250x25350 vdd gnd FILL
XFILL_0_BUFX2_insert5 vdd gnd FILL
XFILL_0__2051_ vdd gnd FILL
X_3300_ _3303_/B _3301_/C vdd gnd INVX1
X_3162_ _3162_/A _3162_/B _3162_/Y vdd gnd NOR2X1
X_3231_ _3628_/A _3628_/B _3313_/S _3232_/B vdd gnd MUX2X1
X_3093_ _3098_/A _3098_/B _3412_/C vdd gnd NOR2X1
XFILL_0__3436_ vdd gnd FILL
X_2113_ _2129_/A _2113_/B _2116_/A vdd gnd NOR2X1
X_2044_ _2044_/A _2044_/B _2045_/B _2045_/C vdd gnd OAI21X1
XFILL_0__3505_ vdd gnd FILL
X_2946_ _2947_/A _2947_/B _2946_/C _2947_/C vdd gnd OAI21X1
X_2877_ _2877_/A _3165_/C _3879_/D vdd gnd AND2X2
X_3995_ _3995_/D _4041_/CLK _3995_/Q vdd gnd DFFPOSX1
X_3429_ _3429_/A _3429_/B _3448_/B _3430_/B vdd gnd MUX2X1
X_2731_ _3947_/Q _3945_/Q _2751_/S _2733_/B vdd gnd MUX2X1
X_2800_ _3915_/Q _2801_/A _2801_/C vdd gnd NAND2X1
X_3780_ _3914_/R vdd _3780_/D _4092_/CLK _3780_/Q vdd gnd DFFSR
XFILL_0_BUFX2_insert164 vdd gnd FILL
X_2593_ _2593_/A _2593_/B _2593_/C _2594_/A vdd gnd AOI21X1
X_2662_ _2662_/A _3902_/R _3983_/D vdd gnd AND2X2
XFILL_0__2936_ vdd gnd FILL
X_3214_ _3214_/A _3293_/B _3258_/C _3214_/D _4098_/D vdd gnd AOI22X1
X_3145_ _3651_/A _3651_/B _3279_/S _3146_/A vdd gnd MUX2X1
X_3076_ _3076_/A _3752_/Q _3079_/D vdd gnd AND2X2
XFILL_0__3419_ vdd gnd FILL
X_2027_ _2123_/A _2027_/B _2028_/B vdd gnd NOR2X1
XBUFX2_insert26 i_rst_n _2952_/C vdd gnd BUFX2
X_2929_ _3850_/Q _2937_/S _2930_/C vdd gnd NAND2X1
X_3978_ _3978_/D _3685_/A _3978_/Q vdd gnd DFFPOSX1
XBUFX2_insert15 _3075_/Y _3585_/B vdd gnd BUFX2
XBUFX2_insert59 _3730_/Q _3465_/A vdd gnd BUFX2
XBUFX2_insert37 _3624_/Y _3712_/S vdd gnd BUFX2
XFILL_0__2721_ vdd gnd FILL
X_3901_ _3901_/D _3907_/CLK _3901_/Q vdd gnd DFFPOSX1
X_2714_ _2714_/A _2913_/B _3959_/D vdd gnd AND2X2
X_3832_ _3832_/D _4025_/CLK _3832_/Q vdd gnd DFFPOSX1
XFILL_0__3204_ vdd gnd FILL
X_3763_ _3763_/D _3162_/A _3763_/Q vdd gnd DFFPOSX1
XFILL_0__3135_ vdd gnd FILL
X_3694_ _3694_/A _3694_/B _3694_/C _3695_/A vdd gnd OAI21X1
X_2645_ _3988_/Q _4007_/Q _2646_/B vdd gnd NAND2X1
X_2576_ _3221_/A _3004_/B _4011_/Q _2581_/B vdd gnd OAI21X1
X_3128_ _3701_/Y _3673_/Y _3165_/C _3129_/C vdd gnd OAI21X1
X_3059_ _3059_/A _3059_/B _3062_/C _3781_/D vdd gnd AOI21X1
X_2361_ _4027_/Q _2363_/A vdd gnd INVX1
X_2430_ _3412_/A _3403_/A vdd gnd INVX1
XFILL_0__2704_ vdd gnd FILL
XFILL_0__2635_ vdd gnd FILL
X_2292_ _2516_/A _2516_/B _2292_/C _2296_/A vdd gnd OAI21X1
X_4100_ _4100_/D _4100_/CLK _4100_/Q vdd gnd DFFPOSX1
XFILL_0__3684_ vdd gnd FILL
X_4031_ _4031_/D _4058_/CLK _4031_/Q vdd gnd DFFPOSX1
XFILL_0__3049_ vdd gnd FILL
X_3815_ _3815_/D _4076_/CLK _3815_/Q vdd gnd DFFPOSX1
X_3677_ _3837_/Q _3680_/B _3678_/A vdd gnd NOR2X1
XFILL_0__3118_ vdd gnd FILL
X_3746_ _3914_/R vdd _3746_/D _4072_/CLK _3746_/Q vdd gnd DFFSR
X_2559_ _3801_/Q _3803_/Q _3024_/A vdd gnd NAND2X1
X_2628_ _3844_/Q _2944_/B _2947_/B vdd gnd NAND2X1
XFILL_0_CLKBUF1_insert156 vdd gnd FILL
XFILL_0_CLKBUF1_insert145 vdd gnd FILL
XFILL_0__2420_ vdd gnd FILL
X_1930_ _3713_/Q _1930_/B _3084_/S _1931_/B vdd gnd MUX2X1
X_1861_ _2373_/Y o_rf_sck vdd gnd BUFX2
X_3531_ _3531_/A _3531_/B _3531_/S _3928_/D vdd gnd MUX2X1
X_3600_ _3825_/Q _3603_/C vdd gnd INVX1
X_2344_ _2589_/A _4020_/Q _2346_/A vdd gnd OR2X2
X_3462_ _3462_/A _3462_/B _3470_/S _3962_/D vdd gnd MUX2X1
X_3393_ _3393_/A _3393_/B _3393_/S _3823_/D vdd gnd MUX2X1
X_2413_ _2413_/A _2413_/B _2413_/Y vdd gnd NAND2X1
X_4014_ _4014_/D _4014_/CLK _4014_/Q vdd gnd DFFPOSX1
XFILL_0_BUFX2_insert69 vdd gnd FILL
XFILL_0_BUFX2_insert25 vdd gnd FILL
XFILL_0_BUFX2_insert14 vdd gnd FILL
XFILL_0__3598_ vdd gnd FILL
XFILL_0_BUFX2_insert58 vdd gnd FILL
XFILL_0__2549_ vdd gnd FILL
XFILL_0__3667_ vdd gnd FILL
XFILL_0_BUFX2_insert36 vdd gnd FILL
X_2275_ _3735_/Q _3279_/S _2275_/Y vdd gnd NOR2X1
X_3729_ _3729_/D _4016_/CLK _3729_/Q vdd gnd DFFPOSX1
XFILL_0__1920_ vdd gnd FILL
XFILL_0__2403_ vdd gnd FILL
X_2060_ _2060_/A _2060_/B _2133_/B _2061_/C vdd gnd OAI21X1
XFILL_0__3452_ vdd gnd FILL
XFILL_0__2334_ vdd gnd FILL
X_2893_ _2893_/A _2917_/B _3871_/D vdd gnd AND2X2
X_2962_ _3902_/R _3829_/Q _2967_/B vdd gnd NAND2X1
XFILL_0__3383_ vdd gnd FILL
X_1913_ _3607_/A _2192_/C _1913_/C _1914_/B vdd gnd OAI21X1
X_3445_ _3445_/A _3445_/B _3445_/C _3445_/D _3970_/D vdd gnd OAI22X1
X_3514_ _3934_/Q _3517_/A vdd gnd INVX1
X_2327_ _3036_/A _3793_/Q _2328_/B vdd gnd OR2X2
X_2258_ _2258_/A _3118_/A _3551_/A _2287_/A vdd gnd OAI21X1
X_3376_ _3993_/Q _3379_/A vdd gnd INVX1
X_2189_ _4036_/Q _2193_/B _2189_/C _2190_/C vdd gnd OAI21X1
XFILL_0__2952_ vdd gnd FILL
XFILL_0__2883_ vdd gnd FILL
X_3161_ _4018_/Q _3162_/B vdd gnd INVX1
XFILL_0__1903_ vdd gnd FILL
X_2112_ _4055_/Q _3964_/Q _2128_/S _2113_/B vdd gnd MUX2X1
X_3230_ _3778_/Q _3628_/A vdd gnd INVX1
X_3092_ _3866_/B _3098_/A vdd gnd INVX1
X_2043_ _2131_/A _2043_/B _2044_/B vdd gnd NOR2X1
XFILL_0__3366_ vdd gnd FILL
X_2945_ _2945_/A _3844_/D vdd gnd INVX1
X_3994_ _3994_/D _4014_/CLK _3994_/Q vdd gnd DFFPOSX1
X_2876_ _2880_/A _2876_/B _2876_/C _2877_/A vdd gnd OAI21X1
XFILL_0__3297_ vdd gnd FILL
XFILL_0__2179_ vdd gnd FILL
XFILL_0__2248_ vdd gnd FILL
X_3428_ _3428_/A _3428_/B _3429_/B vdd gnd NOR2X1
X_3359_ _3359_/A _3361_/A _3365_/S _4013_/D vdd gnd MUX2X1
X_2730_ _2730_/A _2782_/B _3951_/D vdd gnd AND2X2
X_2661_ _2661_/A _3984_/D vdd gnd INVX1
XFILL_0_BUFX2_insert176 vdd gnd FILL
XFILL_0__2102_ vdd gnd FILL
XFILL_0__2033_ vdd gnd FILL
XFILL_0__3082_ vdd gnd FILL
XFILL_0__3151_ vdd gnd FILL
X_2592_ _3705_/B _2660_/B _2593_/A vdd gnd NOR2X1
XFILL_0__2797_ vdd gnd FILL
X_3213_ _4100_/Q _3213_/B _3213_/C _3214_/D vdd gnd OAI21X1
X_3075_ _3857_/Y _3075_/B _3845_/A _3075_/Y vdd gnd OAI21X1
X_3144_ _3890_/Q _3651_/A vdd gnd INVX1
X_3977_ _3977_/D _4076_/CLK _3977_/Q vdd gnd DFFPOSX1
X_2026_ _4033_/Q _3876_/Q _2122_/S _2027_/B vdd gnd MUX2X1
X_2928_ _3848_/Q _2934_/A vdd gnd INVX1
X_2859_ _3887_/Q _2864_/A _2860_/C vdd gnd NAND2X1
XBUFX2_insert27 i_rst_n _3165_/C vdd gnd BUFX2
XBUFX2_insert16 _3075_/Y _3611_/B vdd gnd BUFX2
XBUFX2_insert38 _3624_/Y _3653_/S vdd gnd BUFX2
XFILL_0__2651_ vdd gnd FILL
XFILL_0__2582_ vdd gnd FILL
X_3900_ _3900_/D _3900_/CLK _3900_/Q vdd gnd DFFPOSX1
X_3831_ _3831_/D _4008_/CLK _3831_/Q vdd gnd DFFPOSX1
XFILL_0__3065_ vdd gnd FILL
X_2713_ _2801_/A _2713_/B _2713_/C _2714_/A vdd gnd OAI21X1
X_2644_ _2644_/A _2644_/B _3013_/C _3990_/D vdd gnd AOI21X1
X_3693_ _3694_/A _3878_/Q _3874_/Q _3694_/C vdd gnd NAND3X1
X_3762_ _3910_/R vdd _3762_/D _4072_/CLK _3762_/Q vdd gnd DFFSR
X_2575_ _3003_/C _2575_/B _2967_/C _4012_/D vdd gnd OAI21X1
XFILL_0__2918_ vdd gnd FILL
X_3058_ _3070_/B _3058_/B _3063_/C _3059_/A vdd gnd NAND3X1
X_3127_ _3702_/Y _3699_/Y _3707_/Y _3129_/A vdd gnd NAND3X1
X_2009_ _2169_/A _2009_/B _2012_/A vdd gnd NOR2X1
X_2360_ _3070_/B _3066_/B _3066_/A _3064_/B vdd gnd NAND3X1
X_2291_ _3281_/C _2352_/B _2291_/C _2516_/B vdd gnd AOI21X1
X_4030_ _4030_/D _2373_/A _4030_/Q vdd gnd DFFPOSX1
XFILL_0__2496_ vdd gnd FILL
X_3814_ _3814_/A _3857_/Y _3841_/A vdd gnd NAND2X1
X_2627_ _2942_/A _2942_/B _2944_/B vdd gnd NOR2X1
X_3676_ _3684_/B _3710_/B vdd gnd INVX1
X_3745_ _3745_/D _3162_/A _3745_/Q vdd gnd DFFPOSX1
X_2558_ _2558_/A _3706_/B _3073_/A _4015_/D vdd gnd AOI21X1
X_2489_ _3373_/C _3866_/A _2489_/C _2490_/A vdd gnd AOI21X1
XFILL128850x57750 vdd gnd FILL
X_1860_ _4030_/Q o_rf_sync vdd gnd BUFX2
XFILL_0__2350_ vdd gnd FILL
XFILL_0__2281_ vdd gnd FILL
X_3530_ _3540_/A _3930_/Q _3530_/C _3531_/B vdd gnd OAI21X1
X_3461_ _3488_/A _3964_/Q _3461_/C _3462_/B vdd gnd OAI21X1
X_2343_ _2343_/A _2343_/B _2589_/A vdd gnd NOR2X1
X_2274_ _3706_/A _3706_/B _2289_/A _2274_/Y vdd gnd OAI21X1
X_4013_ _4013_/D _4045_/CLK _4013_/Q vdd gnd DFFPOSX1
XFILL_0__1996_ vdd gnd FILL
X_3392_ _4000_/Q _3403_/B _3396_/C _3393_/A vdd gnd AOI21X1
X_2412_ _2412_/A _2412_/B _2413_/A vdd gnd NAND2X1
XFILL_0__2617_ vdd gnd FILL
X_1989_ _3644_/B _2085_/B _1989_/C _1990_/A vdd gnd OAI21X1
X_3659_ _3660_/Y _3664_/Y _3668_/Y _3827_/D vdd gnd AOI21X1
X_3728_ _3910_/R vdd _3728_/D _3985_/CLK _3728_/Q vdd gnd DFFSR
XFILL128850x32550 vdd gnd FILL
XFILL128850x122550 vdd gnd FILL
XFILL_0__3520_ vdd gnd FILL
X_2892_ _2896_/A _2892_/B _2892_/C _2893_/A vdd gnd OAI21X1
X_2961_ _3014_/B _2961_/B _2961_/C _3832_/D vdd gnd AOI21X1
X_1912_ _3159_/B _1912_/B _1912_/C _1913_/C vdd gnd NAND3X1
XFILL_0__2195_ vdd gnd FILL
X_3444_ _3551_/A _4057_/Q _3445_/B _3445_/D vdd gnd OAI21X1
X_3513_ _3513_/A _3513_/B _3545_/S _3936_/D vdd gnd MUX2X1
X_2326_ _3793_/Q _3036_/A _2328_/A vdd gnd NAND2X1
X_2257_ _2463_/B _3189_/A _3853_/A _2258_/A vdd gnd AOI21X1
XFILL_0__3649_ vdd gnd FILL
X_3375_ _3393_/B _3375_/B _3393_/S _3997_/D vdd gnd MUX2X1
X_2188_ _3083_/A _2188_/B _2188_/C _2190_/B vdd gnd OAI21X1
XFILL_0_BUFX2_insert7 vdd gnd FILL
X_3091_ _3706_/B _3091_/B _3118_/C _3757_/D vdd gnd AOI21X1
X_2042_ _4037_/Q _3884_/Q _2090_/S _2043_/B vdd gnd MUX2X1
X_2111_ _4052_/Q _3628_/B vdd gnd INVX1
X_3160_ _3160_/A _3160_/B _3707_/A _4016_/D vdd gnd AOI21X1
XFILL_0__3503_ vdd gnd FILL
XFILL_0__2316_ vdd gnd FILL
XFILL_0__3434_ vdd gnd FILL
X_3993_ _3993_/D _4041_/CLK _3993_/Q vdd gnd DFFPOSX1
X_2944_ _3844_/Q _2944_/B _2944_/C _2945_/A vdd gnd OAI21X1
X_2875_ _3879_/Q _2880_/A _2876_/C vdd gnd NAND2X1
X_3358_ _4013_/Q _3361_/A vdd gnd INVX1
X_3427_ _3431_/B _3433_/B _3428_/B vdd gnd NOR2X1
X_2309_ _2351_/A _2590_/A _2310_/C vdd gnd NAND2X1
X_3289_ _4070_/Q _3301_/B _3289_/C _3296_/B vdd gnd NAND3X1
XFILL128550x54150 vdd gnd FILL
X_2660_ _3914_/R _2660_/B _2661_/A vdd gnd NAND2X1
XFILL_0_BUFX2_insert100 vdd gnd FILL
XFILL_0_BUFX2_insert111 vdd gnd FILL
X_2591_ _3705_/B _2660_/B _4005_/Q _2594_/B vdd gnd OAI21X1
XFILL_0__2934_ vdd gnd FILL
X_3212_ _4098_/Q _3214_/A vdd gnd INVX1
XFILL_0__2865_ vdd gnd FILL
X_2025_ _2049_/A _2025_/B _2028_/A vdd gnd NOR2X1
X_3143_ _4099_/Q _3651_/B vdd gnd INVX1
X_3074_ _3767_/Q _3611_/C vdd gnd INVX1
X_2927_ _2927_/A _2927_/B _3118_/C _3854_/D vdd gnd AOI21X1
X_3976_ _3976_/D _3685_/A _3976_/Q vdd gnd DFFPOSX1
XFILL_0__3348_ vdd gnd FILL
XFILL_0__3279_ vdd gnd FILL
XBUFX2_insert28 i_rst_n _2782_/B vdd gnd BUFX2
X_2789_ _2792_/B _2789_/B _2789_/C _2790_/A vdd gnd OAI21X1
X_2858_ _3885_/Q _3883_/Q _2890_/S _2860_/B vdd gnd MUX2X1
XBUFX2_insert17 _3075_/Y _3614_/B vdd gnd BUFX2
XBUFX2_insert39 _3624_/Y _3646_/S vdd gnd BUFX2
XFILL_0__3202_ vdd gnd FILL
XFILL_0__3133_ vdd gnd FILL
X_3830_ _3830_/D _3900_/CLK _3830_/Q vdd gnd DFFPOSX1
X_3761_ _3761_/D _4016_/CLK _3761_/Q vdd gnd DFFPOSX1
X_2712_ _3959_/Q _2801_/A _2713_/C vdd gnd NAND2X1
X_2574_ _3902_/R _3014_/B _2967_/C vdd gnd NAND2X1
X_2643_ _3309_/B _3262_/B _2644_/A vdd gnd NAND2X1
XFILL_0__2015_ vdd gnd FILL
X_3692_ _3717_/Q _3719_/Q _3694_/B vdd gnd NAND2X1
XFILL_0__2848_ vdd gnd FILL
XFILL_0__2779_ vdd gnd FILL
X_3057_ _3781_/Q _3064_/B _3059_/B vdd gnd NAND2X1
X_2008_ _4081_/Q _3938_/Q _2136_/S _2009_/B vdd gnd MUX2X1
X_3126_ _3745_/Q _3129_/B vdd gnd INVX1
X_3959_ _3959_/D _3959_/CLK _3959_/Q vdd gnd DFFPOSX1
XFILL129150x118950 vdd gnd FILL
XFILL_0__2702_ vdd gnd FILL
X_2290_ _2290_/A _2291_/C vdd gnd INVX1
XFILL_0__3682_ vdd gnd FILL
XFILL_0__2564_ vdd gnd FILL
XFILL_0__2633_ vdd gnd FILL
X_3813_ _3813_/D _3821_/CLK _3813_/Q vdd gnd DFFPOSX1
X_3744_ _3906_/R vdd _3744_/D _3938_/CLK _3744_/Q vdd gnd DFFSR
X_2626_ _4025_/Q _2660_/B _2942_/B vdd gnd NAND2X1
XFILL_0__3047_ vdd gnd FILL
X_2557_ _2557_/A _2557_/B _3281_/C _2558_/A vdd gnd NAND3X1
X_3675_ _3837_/Q _3680_/B _3684_/B vdd gnd NAND2X1
X_2488_ _3617_/A _2490_/B vdd gnd INVX1
XFILL_0_CLKBUF1_insert136 vdd gnd FILL
X_3109_ _3109_/A _3618_/B _3110_/A _3110_/D vdd gnd AOI21X1
X_4089_ _4089_/D _4093_/CLK _4089_/Q vdd gnd DFFPOSX1
XFILL_0_CLKBUF1_insert125 vdd gnd FILL
XFILL_0_CLKBUF1_insert158 vdd gnd FILL
XFILL_0_CLKBUF1_insert147 vdd gnd FILL
X_3460_ _3488_/A _3635_/B _3461_/C vdd gnd NAND2X1
X_3391_ _3394_/A _3391_/B _3396_/C vdd gnd AND2X2
X_2411_ _3814_/A _3853_/Y _3857_/Y _2412_/B vdd gnd AOI21X1
X_2342_ _2342_/A _3033_/B vdd gnd INVX1
X_4012_ _4012_/D _4014_/CLK _4012_/Q vdd gnd DFFPOSX1
X_2273_ _2374_/B _3706_/A vdd gnd INVX1
XFILL_0_BUFX2_insert27 vdd gnd FILL
XFILL_0_BUFX2_insert16 vdd gnd FILL
XFILL_0_BUFX2_insert38 vdd gnd FILL
XFILL_0__2547_ vdd gnd FILL
XFILL_0__3596_ vdd gnd FILL
XFILL_0__2478_ vdd gnd FILL
X_3727_ _3727_/D _4016_/CLK _3727_/Q vdd gnd DFFPOSX1
X_1988_ _1988_/A _1988_/B _2085_/B _1989_/C vdd gnd OAI21X1
XFILL129150x36150 vdd gnd FILL
X_2609_ _3061_/B _3048_/B _2610_/C vdd gnd NOR2X1
X_3589_ _3591_/C _3613_/B _3589_/C _3613_/D _3851_/D vdd gnd OAI22X1
X_3658_ _3729_/Q _3660_/Y _3671_/Y _3658_/Y vdd gnd OAI21X1
XFILL_0__2332_ vdd gnd FILL
X_2960_ _3832_/Q _3014_/B _3902_/R _2961_/C vdd gnd OAI21X1
XFILL_0__2401_ vdd gnd FILL
XFILL_0__3381_ vdd gnd FILL
XFILL_0__3450_ vdd gnd FILL
X_2891_ _3871_/Q _2896_/A _2892_/C vdd gnd NAND2X1
XFILL_0__2263_ vdd gnd FILL
X_1911_ _1911_/A _3083_/A _1912_/C vdd gnd NOR2X1
X_3443_ _3443_/A _3443_/B _3443_/C _3445_/C vdd gnd AOI21X1
X_3512_ _3521_/A _3938_/Q _3512_/C _3513_/B vdd gnd OAI21X1
X_3374_ _3398_/A _3374_/B _3403_/B _3393_/S vdd gnd MUX2X1
X_2325_ _3999_/Q _3844_/Q _2325_/C _3036_/A vdd gnd OAI21X1
X_2256_ _3738_/Q _3849_/Y _3189_/A vdd gnd NOR2X1
XFILL_0__1978_ vdd gnd FILL
X_2187_ _2187_/A _2237_/B _2187_/S _2188_/B vdd gnd MUX2X1
XFILL_0__2881_ vdd gnd FILL
X_3090_ _3090_/A _3866_/B _3982_/Q _3091_/B vdd gnd AOI21X1
X_2110_ _2110_/A _2134_/B _4055_/D vdd gnd AND2X2
X_2041_ _2081_/A _2041_/B _2044_/A vdd gnd NOR2X1
X_2943_ _2944_/B _3844_/Q _2943_/C _2944_/C vdd gnd AOI21X1
X_3992_ _3992_/D _4014_/CLK _3992_/Q vdd gnd DFFPOSX1
XFILL_0__2246_ vdd gnd FILL
XFILL_0__3295_ vdd gnd FILL
X_2874_ _3877_/Q _3875_/Q _2890_/S _2876_/B vdd gnd MUX2X1
XFILL_0__2177_ vdd gnd FILL
X_2308_ _3999_/Q _3275_/A _2351_/A vdd gnd NOR2X1
X_3426_ _3426_/A _3433_/B vdd gnd INVX1
X_3357_ _3357_/A _3359_/A _3377_/S _4017_/D vdd gnd MUX2X1
X_3288_ _4068_/Q _3293_/A vdd gnd INVX1
X_2239_ _3412_/B _3413_/B _2285_/B _2242_/C vdd gnd NAND3X1
XFILL_0__2100_ vdd gnd FILL
X_2590_ _2590_/A _2660_/B vdd gnd INVX1
XFILL_0_BUFX2_insert178 vdd gnd FILL
XFILL_0__2031_ vdd gnd FILL
XFILL_0_BUFX2_insert167 vdd gnd FILL
XFILL_0__3080_ vdd gnd FILL
X_3211_ _3211_/A _3293_/B _3211_/C _3211_/D _4100_/D vdd gnd AOI22X1
X_3142_ _3142_/A _3688_/A _3289_/C _3741_/D vdd gnd MUX2X1
X_3073_ _3073_/A _3073_/B _3073_/C _3769_/D vdd gnd NOR3X1
XFILL_0__2795_ vdd gnd FILL
X_2024_ _4077_/Q _3942_/Q _2064_/S _2025_/B vdd gnd MUX2X1
XFILL_0__3416_ vdd gnd FILL
X_3975_ _3975_/D _3986_/CLK _3975_/Q vdd gnd DFFPOSX1
X_2926_ _3854_/Q _2926_/B _2927_/A vdd gnd NAND2X1
X_2857_ _2857_/A _2917_/B _3889_/D vdd gnd AND2X2
XBUFX2_insert18 _3075_/Y _3609_/B vdd gnd BUFX2
XBUFX2_insert29 i_rst_n _2134_/B vdd gnd BUFX2
X_2788_ _3921_/Q _2792_/B _2789_/C vdd gnd NAND2X1
X_3409_ _3552_/A _3918_/Q _3409_/C _3410_/B vdd gnd OAI21X1
XFILL_0__2580_ vdd gnd FILL
X_2711_ _3957_/Q _3955_/Q _2767_/S _2713_/B vdd gnd MUX2X1
X_3760_ _3902_/R vdd _3760_/D _4072_/CLK _3760_/Q vdd gnd DFFSR
X_2573_ _2573_/A _2575_/B vdd gnd INVX1
X_3691_ _3691_/A _3691_/B _3691_/C _3691_/D _3697_/B vdd gnd AOI22X1
X_2642_ _3631_/A _3631_/B _3708_/A _3309_/B vdd gnd MUX2X1
XFILL_0__2916_ vdd gnd FILL
X_3125_ _3671_/Y _3179_/A _3125_/C _3747_/D vdd gnd AOI21X1
X_3056_ _3056_/A _3056_/B _3062_/C _3783_/D vdd gnd AOI21X1
XFILL128850x150 vdd gnd FILL
X_2007_ _4079_/Q _3641_/B vdd gnd INVX1
X_2909_ _2909_/A _2913_/B _3863_/D vdd gnd AND2X2
X_3889_ _3889_/D _3889_/CLK _3889_/Q vdd gnd DFFPOSX1
X_3958_ _3958_/D _3980_/CLK _3958_/Q vdd gnd DFFPOSX1
XFILL_0__2494_ vdd gnd FILL
X_3674_ _3833_/Q _3828_/Q _3680_/B vdd gnd AND2X2
X_3743_ _3743_/D _4098_/CLK _3743_/Q vdd gnd DFFPOSX1
XFILL_0__3115_ vdd gnd FILL
X_3812_ _3812_/D _4008_/CLK _3812_/Q vdd gnd DFFPOSX1
X_2625_ _3846_/Q _2942_/A vdd gnd INVX1
X_2556_ _2675_/A _2675_/B _2557_/B vdd gnd NAND2X1
X_2487_ _3866_/A _3373_/C _2489_/C _3617_/A vdd gnd NAND3X1
X_3108_ _3109_/A _3618_/B _3110_/C vdd gnd OR2X2
X_4088_ _4088_/D _4092_/CLK _4088_/Q vdd gnd DFFPOSX1
X_3039_ _3039_/A _3039_/B _3062_/C _3793_/D vdd gnd AOI21X1
X_2341_ _3795_/Q _2346_/D vdd gnd INVX1
XFILL_0__3802_ vdd gnd FILL
X_3390_ _3390_/A _3390_/B _3403_/B _3391_/B vdd gnd AOI21X1
X_2410_ _3814_/A _3412_/B _2410_/C _2413_/B vdd gnd NAND3X1
XFILL_0__2615_ vdd gnd FILL
X_4011_ _4011_/D _4084_/CLK _4011_/Q vdd gnd DFFPOSX1
X_2272_ _2272_/A _3617_/C _2374_/B vdd gnd NOR2X1
XFILL_0__3664_ vdd gnd FILL
XFILL_0__3029_ vdd gnd FILL
X_3726_ _3726_/D _3938_/CLK _3726_/Q vdd gnd DFFPOSX1
X_1987_ _2083_/A _1987_/B _1988_/B vdd gnd NOR2X1
X_3657_ _3657_/A _3657_/B _3712_/S _3874_/D vdd gnd MUX2X1
X_2539_ _4023_/Q _2539_/B _3914_/R _2540_/B vdd gnd OAI21X1
X_2608_ _2608_/A _3061_/B vdd gnd INVX1
X_3588_ _3851_/Q _3591_/C vdd gnd INVX1
XFILL128550x39750 vdd gnd FILL
XFILL128550x82950 vdd gnd FILL
X_2890_ _3869_/Q _3867_/Q _2890_/S _2892_/B vdd gnd MUX2X1
X_1910_ i_mem_miso _1910_/B _1911_/A vdd gnd NAND2X1
XFILL_0__2193_ vdd gnd FILL
X_3511_ _3521_/A _3648_/B _3512_/C vdd gnd NAND2X1
X_2324_ _2529_/A _3838_/Q _2325_/C vdd gnd OR2X2
X_3373_ _3870_/A _3870_/B _3373_/C _3374_/B vdd gnd OAI21X1
X_3442_ _3442_/A _3443_/A _3551_/A _3443_/C vdd gnd OAI21X1
X_2255_ _3732_/Q _3134_/A _2463_/B vdd gnd NOR2X1
X_2186_ _3985_/Q _2237_/B vdd gnd INVX1
XFILL_0__3578_ vdd gnd FILL
XFILL_0__3647_ vdd gnd FILL
XFILL_0__2529_ vdd gnd FILL
X_3709_ _3709_/A _3709_/B _3798_/D vdd gnd NAND2X1
XFILL_0__1900_ vdd gnd FILL
XFILL_0__3432_ vdd gnd FILL
X_2040_ _4073_/Q _3946_/Q _2064_/S _2041_/B vdd gnd MUX2X1
XFILL_0__3501_ vdd gnd FILL
X_2942_ _2942_/A _2942_/B _2942_/C _3846_/D vdd gnd AOI21X1
XFILL_0__2314_ vdd gnd FILL
X_2873_ _2873_/A _3165_/C _3881_/D vdd gnd AND2X2
XFILL_0__3363_ vdd gnd FILL
X_3991_ _3991_/D _3997_/CLK _3991_/Q vdd gnd DFFPOSX1
X_2307_ _2528_/A _2310_/B vdd gnd INVX1
X_3287_ _3289_/C _3287_/B _3287_/C _4070_/D vdd gnd OAI21X1
X_2238_ _2238_/A _2238_/B _2285_/B vdd gnd NAND2X1
X_3356_ _4017_/Q _3359_/A vdd gnd INVX1
X_3425_ _3442_/A _3432_/B _3426_/A vdd gnd NAND2X1
X_2169_ _2169_/A _2169_/B _2170_/A vdd gnd NOR2X1
XFILL_0__2932_ vdd gnd FILL
X_3210_ _3714_/Q _3213_/B _3213_/C _3211_/D vdd gnd OAI21X1
XFILL_0__2863_ vdd gnd FILL
X_3141_ _4097_/Q _3279_/S _3141_/C _3688_/A vdd gnd OAI21X1
X_3072_ _3072_/A _3073_/B vdd gnd INVX1
XFILL_0__3346_ vdd gnd FILL
X_2023_ _4075_/Q _3639_/B vdd gnd INVX1
X_2925_ _2937_/S _2931_/B _2925_/C _2927_/B vdd gnd OAI21X1
X_2856_ _2908_/A _2856_/B _2856_/C _2857_/A vdd gnd OAI21X1
XFILL_0__3277_ vdd gnd FILL
XFILL_0__2228_ vdd gnd FILL
XBUFX2_insert19 _3556_/Y _3609_/D vdd gnd BUFX2
X_3974_ _3974_/D _3980_/CLK _3974_/Q vdd gnd DFFPOSX1
XFILL_0__2159_ vdd gnd FILL
X_2787_ _3919_/Q _3917_/Q _2906_/S _2789_/B vdd gnd MUX2X1
X_3408_ _3552_/A _3625_/B _3409_/C vdd gnd NAND2X1
X_3339_ _3339_/A _3341_/A _3351_/S _4037_/D vdd gnd MUX2X1
XFILL_0__3200_ vdd gnd FILL
X_2710_ _2710_/A _2913_/B _3961_/D vdd gnd AND2X2
XFILL_0__3062_ vdd gnd FILL
X_3690_ _3691_/A _3690_/B _3690_/C _3691_/C vdd gnd NAND3X1
XFILL_0__2013_ vdd gnd FILL
XFILL_0__3131_ vdd gnd FILL
X_2572_ _2966_/B _2966_/A _2573_/A vdd gnd NOR2X1
X_2641_ _3772_/Q _3631_/A vdd gnd INVX1
XFILL_0__2777_ vdd gnd FILL
X_3055_ _3070_/B _3055_/B _3063_/C _3056_/A vdd gnd NAND3X1
X_3124_ _3124_/A _3841_/Y _3165_/C _3125_/C vdd gnd OAI21X1
X_3957_ _3957_/D _3959_/CLK _3957_/Q vdd gnd DFFPOSX1
X_2006_ _2006_/A _2189_/C _4081_/D vdd gnd AND2X2
X_2908_ _2908_/A _2908_/B _2908_/C _2909_/A vdd gnd OAI21X1
X_2839_ _3897_/Q _2912_/A _2840_/C vdd gnd NAND2X1
XFILL129150x64950 vdd gnd FILL
X_3888_ _3888_/D _4047_/CLK _3888_/Q vdd gnd DFFPOSX1
XFILL_0__2631_ vdd gnd FILL
XFILL_0__2562_ vdd gnd FILL
XFILL_0__3680_ vdd gnd FILL
X_3811_ _3811_/D _4025_/CLK _3811_/Q vdd gnd DFFPOSX1
X_2624_ _3842_/Q _2947_/A vdd gnd INVX1
XFILL_0__3045_ vdd gnd FILL
X_3673_ _3745_/Q _3699_/Y _3673_/Y vdd gnd NAND2X1
X_3742_ _3742_/D _3997_/CLK _3742_/Q vdd gnd DFFPOSX1
X_2555_ _2676_/B _2557_/A vdd gnd INVX1
X_2486_ _2486_/A _3616_/A _2489_/C vdd gnd NOR2X1
X_3038_ _3793_/Q _3064_/B _3039_/B vdd gnd NAND2X1
X_3107_ _3743_/Q _3107_/B _3107_/C _3109_/A vdd gnd AOI21X1
X_4087_ _4087_/D _4087_/CLK _4087_/Q vdd gnd DFFPOSX1
XFILL_0_CLKBUF1_insert149 vdd gnd FILL
XFILL_0_CLKBUF1_insert127 vdd gnd FILL
XFILL_0_CLKBUF1_insert116 vdd gnd FILL
XFILL_0_CLKBUF1_insert138 vdd gnd FILL
X_2340_ _2340_/A _2340_/B _2347_/C vdd gnd NOR2X1
X_2271_ _2271_/A _2271_/B _3259_/A _2272_/A vdd gnd OAI21X1
XFILL_0__1993_ vdd gnd FILL
XFILL_0_BUFX2_insert18 vdd gnd FILL
X_4010_ _4010_/D _4045_/CLK _4010_/Q vdd gnd DFFPOSX1
XFILL_0__3594_ vdd gnd FILL
XFILL_0_BUFX2_insert29 vdd gnd FILL
X_1986_ _4022_/Q _3855_/Q _2082_/S _1987_/B vdd gnd MUX2X1
XFILL_0__2476_ vdd gnd FILL
X_2607_ _3058_/B _3055_/B _2610_/B vdd gnd NOR2X1
X_3725_ _3725_/D _4016_/CLK _3725_/Q vdd gnd DFFPOSX1
X_3587_ _3589_/C _3613_/B _3587_/C _3613_/D _3855_/D vdd gnd OAI22X1
X_3656_ _3874_/Q _3657_/A vdd gnd INVX1
X_2538_ _2539_/B _2667_/A _2540_/A vdd gnd AND2X2
X_2469_ _3754_/Q _3138_/A _2469_/C _3623_/B vdd gnd OAI21X1
XFILL_0__2330_ vdd gnd FILL
XFILL_0__2261_ vdd gnd FILL
X_3441_ _3441_/A _3441_/B _3443_/B vdd gnd NOR2X1
X_3510_ _3936_/Q _3513_/A vdd gnd INVX1
X_2323_ _2323_/A _2323_/B _2328_/C vdd gnd NOR2X1
X_2254_ _3743_/Q _3134_/A vdd gnd INVX1
XFILL_0__1976_ vdd gnd FILL
X_3372_ _3372_/A _3398_/A vdd gnd INVX2
X_2185_ _2185_/A _2185_/B _2188_/C vdd gnd NAND2X1
X_1969_ _2049_/A _1969_/B _1972_/A vdd gnd NOR2X1
X_3639_ _3639_/A _3639_/B _3650_/S _3749_/D vdd gnd MUX2X1
X_3708_ _3708_/A _3708_/B _3709_/A vdd gnd NAND2X1
X_3990_ _3990_/D _4076_/CLK _3990_/Q vdd gnd DFFPOSX1
X_2941_ _2942_/A _2942_/B _2946_/C _2942_/C vdd gnd OAI21X1
XFILL_0__3293_ vdd gnd FILL
X_2872_ _2880_/A _2872_/B _2872_/C _2873_/A vdd gnd OAI21X1
XFILL_0__2175_ vdd gnd FILL
X_3424_ _3465_/A _3628_/B _3430_/C vdd gnd NAND2X1
X_2306_ _2529_/A _2306_/B _2528_/A vdd gnd NOR2X1
X_2237_ _3429_/A _2237_/B _3428_/A _2238_/B vdd gnd NAND3X1
X_3355_ _3355_/A _3357_/A _3377_/S _4019_/D vdd gnd MUX2X1
X_3286_ _4044_/Q _3694_/A _3286_/C _3287_/B vdd gnd OAI21X1
X_2099_ _2123_/A _2099_/B _2100_/B vdd gnd NOR2X1
X_2168_ _2168_/A _3431_/B _2187_/S _2169_/B vdd gnd MUX2X1
XFILL_0__3629_ vdd gnd FILL
XFILL_0_BUFX2_insert103 vdd gnd FILL
XFILL_0_BUFX2_insert169 vdd gnd FILL
XFILL_0_BUFX2_insert114 vdd gnd FILL
X_3071_ _3073_/A _3071_/B _3073_/C _3771_/D vdd gnd NOR3X1
X_3140_ _3279_/S _3650_/A _3141_/C vdd gnd NAND2X1
X_3973_ _3973_/D _3986_/CLK _3973_/Q vdd gnd DFFPOSX1
X_2022_ _2022_/A _2134_/B _4077_/D vdd gnd AND2X2
XFILL_0__3414_ vdd gnd FILL
X_2924_ _2937_/S _2936_/A _2924_/C _2925_/C vdd gnd OAI21X1
X_2855_ _3889_/Q _2908_/A _2856_/C vdd gnd NAND2X1
X_2786_ _2786_/A _2917_/B _3923_/D vdd gnd AND2X2
X_3338_ _4037_/Q _3341_/A vdd gnd INVX1
X_3407_ _3987_/Q _3553_/B _3410_/C vdd gnd NAND2X1
X_3269_ _3646_/A _3646_/B _3313_/S _3271_/B vdd gnd MUX2X1
X_2640_ _3221_/A _3708_/B _3990_/Q _2644_/B vdd gnd OAI21X1
X_2571_ _3025_/A _2571_/B _4014_/D vdd gnd NOR2X1
XFILL_0__2914_ vdd gnd FILL
X_3054_ _3783_/Q _3064_/B _3056_/B vdd gnd NAND2X1
XFILL_0__2845_ vdd gnd FILL
X_2005_ _3642_/B _2045_/B _2005_/C _2006_/A vdd gnd OAI21X1
X_3123_ _3672_/Y _3124_/A vdd gnd INVX1
X_2907_ _3863_/Q _2908_/A _2908_/C vdd gnd NAND2X1
XFILL_0__3259_ vdd gnd FILL
XFILL_0__3328_ vdd gnd FILL
X_3956_ _3956_/D _3964_/CLK _3956_/Q vdd gnd DFFPOSX1
X_2769_ _2769_/A _2769_/B _2769_/C _2770_/A vdd gnd OAI21X1
X_2838_ _3895_/Q _3893_/Q _2918_/S _2840_/B vdd gnd MUX2X1
X_3887_ _3887_/D _3889_/CLK _3887_/Q vdd gnd DFFPOSX1
XFILL_0__3113_ vdd gnd FILL
X_3741_ _3741_/D _4080_/CLK _3741_/Q vdd gnd DFFPOSX1
X_3810_ _3810_/A _3810_/Y vdd gnd INVX1
X_2623_ _2623_/A _2952_/C _3998_/D vdd gnd AND2X2
X_2554_ _2675_/A _2675_/B _2676_/B vdd gnd NOR2X1
X_3672_ _3701_/Y _3673_/Y _3672_/Y vdd gnd NOR2X1
XFILL_0__2828_ vdd gnd FILL
X_2485_ _3808_/Q _4053_/Q _2486_/A vdd gnd NOR2X1
X_3037_ _3070_/B _3037_/B _3063_/C _3039_/A vdd gnd NAND3X1
XFILL_0__2759_ vdd gnd FILL
X_3106_ _3106_/A _3106_/B _3106_/C _3618_/B vdd gnd OAI21X1
X_4086_ _4086_/D _3700_/A _4086_/Q vdd gnd DFFPOSX1
X_3939_ _3939_/D _3943_/CLK _3939_/Q vdd gnd DFFPOSX1
X_2270_ _2395_/B _3246_/A _3849_/Y _3259_/A vdd gnd OAI21X1
XFILL_0__3662_ vdd gnd FILL
XFILL_0__2544_ vdd gnd FILL
XFILL_0__2613_ vdd gnd FILL
XFILL_0_CLKBUF1_insert52 vdd gnd FILL
X_3724_ _3724_/D _4098_/CLK _3724_/Q vdd gnd DFFPOSX1
X_1985_ _2081_/A _1985_/B _1988_/A vdd gnd NOR2X1
XFILL_0__3027_ vdd gnd FILL
X_2606_ _2606_/A _3058_/B vdd gnd INVX1
X_2537_ _2537_/A _2665_/A _2539_/B vdd gnd NOR2X1
X_3586_ _3855_/Q _3589_/C vdd gnd INVX1
X_3655_ _3655_/A _3655_/B _3712_/S _3878_/D vdd gnd MUX2X1
X_2399_ _2418_/B _2416_/C vdd gnd INVX1
X_2468_ _3743_/Q _3412_/A _2469_/C vdd gnd NOR2X1
X_4069_ _4069_/D _4093_/CLK _4069_/Q vdd gnd DFFPOSX1
X_3440_ _3968_/Q _3445_/A _3441_/B vdd gnd NOR2X1
X_3371_ _3371_/A _3372_/A _3371_/C _4000_/D vdd gnd AOI21X1
X_2322_ _3043_/A _3789_/Q _2323_/B vdd gnd AND2X2
X_2253_ _2419_/C _3075_/B _3118_/A vdd gnd NAND2X1
X_2184_ _3742_/Q _3997_/Q _3823_/Q _2185_/A vdd gnd OAI21X1
XFILL_0__2527_ vdd gnd FILL
XFILL_0__2458_ vdd gnd FILL
XFILL_0__3576_ vdd gnd FILL
XFILL_0__2389_ vdd gnd FILL
X_3707_ _3707_/A _3810_/Y _3841_/Y _3707_/Y vdd gnd OAI21X1
X_1968_ _4091_/Q _3928_/Q _2187_/S _1969_/B vdd gnd MUX2X1
X_1899_ _1917_/B _1899_/B _1900_/B vdd gnd NOR2X1
X_3638_ _3638_/A _3638_/B _3653_/S _3751_/D vdd gnd MUX2X1
X_3569_ _3571_/C _3613_/B _3569_/C _3613_/D _3892_/D vdd gnd OAI22X1
XFILL128850x68550 vdd gnd FILL
X_2940_ _2940_/A _3845_/A _3848_/D vdd gnd AND2X2
XFILL_0__2312_ vdd gnd FILL
XFILL_0__3430_ vdd gnd FILL
XFILL_0__3361_ vdd gnd FILL
X_2871_ _3881_/Q _2880_/A _2872_/C vdd gnd NAND2X1
XFILL_0__2243_ vdd gnd FILL
X_3423_ _3423_/A _3429_/A _3445_/B _3980_/D vdd gnd MUX2X1
X_3354_ _4019_/Q _3357_/A vdd gnd INVX1
X_2305_ _3826_/Q _2306_/B vdd gnd INVX1
X_2236_ _3418_/B _3428_/A vdd gnd INVX1
X_2167_ _3974_/Q _3431_/B vdd gnd INVX1
XFILL_0__1958_ vdd gnd FILL
XFILL_0__1889_ vdd gnd FILL
X_3285_ _3694_/A _3712_/A _3286_/C vdd gnd NAND2X1
X_2098_ _4051_/Q _3912_/Q _2122_/S _2099_/B vdd gnd MUX2X1
XFILL_0__2930_ vdd gnd FILL
XFILL_0__2861_ vdd gnd FILL
XFILL_0__2792_ vdd gnd FILL
X_3070_ _3070_/A _3070_/B _3773_/D vdd gnd NOR2X1
X_2021_ _3640_/B _2133_/B _2021_/C _2022_/A vdd gnd OAI21X1
X_2923_ _3852_/Q _2937_/S _2924_/C vdd gnd NAND2X1
XFILL_0__3275_ vdd gnd FILL
X_3972_ _3972_/D _3980_/CLK _3972_/Q vdd gnd DFFPOSX1
X_2785_ _2792_/B _2785_/B _2785_/C _2786_/A vdd gnd OAI21X1
X_2854_ _3887_/Q _3885_/Q _2890_/S _2856_/B vdd gnd MUX2X1
XFILL_0__2226_ vdd gnd FILL
XFILL_0__2088_ vdd gnd FILL
XFILL_0__2157_ vdd gnd FILL
X_3406_ _3445_/B _3553_/B vdd gnd INVX2
X_3337_ _3337_/A _3339_/A _3349_/S _4039_/D vdd gnd MUX2X1
X_2219_ _2516_/A _2280_/B vdd gnd INVX1
X_3199_ _3199_/A _3293_/B _3199_/C _3199_/D _3720_/D vdd gnd AOI22X1
X_3268_ _3910_/Q _3646_/A vdd gnd INVX1
X_2570_ _2966_/B _2966_/A _2952_/C _3025_/A vdd gnd OAI21X1
XFILL_0__3060_ vdd gnd FILL
XFILL_0__2011_ vdd gnd FILL
X_3122_ _3747_/Q _3179_/A vdd gnd INVX1
XFILL_0__2775_ vdd gnd FILL
X_3053_ _3053_/A _3053_/B _3073_/A _3785_/D vdd gnd AOI21X1
X_2004_ _2004_/A _2004_/B _2161_/B _2005_/C vdd gnd OAI21X1
X_3955_ _3955_/D _3955_/CLK _3955_/Q vdd gnd DFFPOSX1
X_2906_ _3860_/Q _3858_/Q _2906_/S _2908_/B vdd gnd MUX2X1
X_3886_ _3906_/R vdd _3886_/D _3938_/CLK _3886_/Q vdd gnd DFFSR
X_2768_ _3931_/Q _2769_/A _2769_/C vdd gnd NAND2X1
X_2699_ _3963_/Q _3961_/Q _2767_/S _2701_/B vdd gnd MUX2X1
X_2837_ _2837_/A _2913_/B _3899_/D vdd gnd AND2X2
XCLKBUF1_insert180 _3822_/Q CLKBUF1_insert180/Y vdd gnd CLKBUF1
XFILL_0__2560_ vdd gnd FILL
XFILL_0__2491_ vdd gnd FILL
X_3740_ _3740_/D _4098_/CLK _3849_/A vdd gnd DFFPOSX1
X_2622_ _2632_/A _2622_/B _2622_/C _2623_/A vdd gnd OAI21X1
X_2553_ _4015_/Q _2675_/B vdd gnd INVX1
X_3671_ _3672_/Y _3707_/Y _3671_/Y vdd gnd NAND2X1
X_3105_ _3788_/Q _3382_/A _3105_/C _3110_/B vdd gnd OAI21X1
X_2484_ _3607_/A _2484_/B _3616_/A vdd gnd NOR2X1
X_4085_ _4085_/D _4087_/CLK _4085_/Q vdd gnd DFFPOSX1
X_3036_ _3036_/A _3037_/B vdd gnd INVX1
XFILL_0_CLKBUF1_insert118 vdd gnd FILL
XFILL_0_CLKBUF1_insert129 vdd gnd FILL
X_3869_ _3869_/D _3893_/CLK _3869_/Q vdd gnd DFFPOSX1
X_3938_ _3938_/D _3938_/CLK _3938_/Q vdd gnd DFFPOSX1
XFILL_0__1991_ vdd gnd FILL
XFILL_0__2474_ vdd gnd FILL
X_3723_ _3723_/D _4016_/CLK _3723_/Q vdd gnd DFFPOSX1
X_1984_ _4087_/Q _3932_/Q _2136_/S _1985_/B vdd gnd MUX2X1
X_3654_ _3878_/Q _3655_/A vdd gnd INVX1
X_2605_ _2605_/A _3055_/B vdd gnd INVX1
X_2536_ i_rf_miso _2667_/A vdd gnd INVX1
X_2467_ _3302_/B _3849_/Y _2492_/A vdd gnd NAND2X1
X_3585_ _3587_/C _3585_/B _3585_/C _3609_/D _3859_/D vdd gnd OAI22X1
X_4068_ _4068_/D _4098_/CLK _4068_/Q vdd gnd DFFPOSX1
X_2398_ _3302_/B _3849_/Y _3298_/B _2418_/B vdd gnd NAND3X1
X_3019_ _3025_/A _3031_/C vdd gnd INVX1
XFILL_0__2190_ vdd gnd FILL
X_2321_ _3789_/Q _3043_/A _2323_/A vdd gnd NOR2X1
X_3370_ _4000_/Q _3372_/A _3371_/C vdd gnd NOR2X1
X_2252_ _3403_/B _3075_/B vdd gnd INVX1
X_2183_ _2183_/A _2189_/C _4038_/D vdd gnd AND2X2
XFILL_0__3644_ vdd gnd FILL
XFILL_0__3009_ vdd gnd FILL
X_3706_ _3706_/A _3706_/B _3706_/C _3806_/D vdd gnd OAI21X1
X_1967_ _4089_/Q _3646_/B vdd gnd INVX1
X_1898_ _1898_/A _2198_/A _1917_/B vdd gnd NOR2X1
X_3637_ _3637_/A _3637_/B _3650_/S _3760_/D vdd gnd MUX2X1
X_2519_ _3773_/Q _3067_/B _2537_/A vdd gnd NAND2X1
X_3568_ _3892_/Q _3571_/C vdd gnd INVX1
X_3499_ _3548_/A _3645_/B _3500_/C vdd gnd NAND2X1
XFILL129150x104550 vdd gnd FILL
X_2870_ _3879_/Q _3877_/Q _2890_/S _2872_/B vdd gnd MUX2X1
XFILL_0__2173_ vdd gnd FILL
X_2304_ _2514_/A _2514_/B _2304_/C _2311_/A vdd gnd OAI21X1
X_3422_ _3465_/A _3422_/B _3422_/C _3423_/A vdd gnd OAI21X1
X_3353_ _3353_/A _3355_/A _3377_/S _4022_/D vdd gnd MUX2X1
X_3284_ _3790_/Q _3712_/A vdd gnd INVX1
XFILL_0__3627_ vdd gnd FILL
X_2235_ _3980_/Q _3418_/B _3985_/Q _2238_/A vdd gnd OAI21X1
XFILL_0__3558_ vdd gnd FILL
X_2097_ _2129_/A _2097_/B _2100_/A vdd gnd NOR2X1
X_2166_ _2185_/B _2166_/B _2170_/B vdd gnd AND2X2
XFILL_0__2509_ vdd gnd FILL
X_2999_ _2999_/A _3009_/B _3811_/Q _3003_/B vdd gnd OAI21X1
XFILL_0__3489_ vdd gnd FILL
XFILL_0_BUFX2_insert105 vdd gnd FILL
X_2020_ _2020_/A _2020_/B _2045_/B _2021_/C vdd gnd OAI21X1
XFILL_0__3412_ vdd gnd FILL
X_3971_ _3971_/D _3986_/CLK _3971_/Q vdd gnd DFFPOSX1
X_2922_ _3850_/Q _2936_/A vdd gnd INVX1
X_2853_ _2853_/A _2917_/B _3891_/D vdd gnd AND2X2
XFILL_0__3343_ vdd gnd FILL
X_2784_ _3923_/Q _2784_/B _2785_/C vdd gnd NAND2X1
XFILL_0__2989_ vdd gnd FILL
X_3267_ _3316_/A _3270_/A _3267_/C _4078_/D vdd gnd AOI21X1
X_3405_ _3448_/B _3470_/S _3445_/B vdd gnd NAND2X1
XFILL128550x150 vdd gnd FILL
X_3336_ _4039_/Q _3339_/A vdd gnd INVX1
X_2218_ _2529_/A _2218_/B _2516_/A vdd gnd NOR2X1
X_3198_ _3722_/Q _3213_/B _3213_/C _3199_/D vdd gnd OAI21X1
X_2149_ _3712_/B _2161_/B _2149_/C _2150_/A vdd gnd OAI21X1
XFILL_0__2912_ vdd gnd FILL
XFILL_0__2843_ vdd gnd FILL
X_3121_ _3810_/Y _3121_/B _3121_/C _3748_/D vdd gnd OAI21X1
X_3052_ _3070_/B _3052_/B _3063_/C _3053_/A vdd gnd NAND3X1
XFILL_0__3326_ vdd gnd FILL
X_2003_ _2131_/A _2003_/B _2004_/B vdd gnd NOR2X1
XFILL_0__2208_ vdd gnd FILL
X_2836_ _2912_/A _2836_/B _2836_/C _2837_/A vdd gnd OAI21X1
X_2905_ _2905_/A _2917_/B _3865_/D vdd gnd AND2X2
X_3885_ _3885_/D _3885_/CLK _3885_/Q vdd gnd DFFPOSX1
XFILL_0__3188_ vdd gnd FILL
XFILL_0__3257_ vdd gnd FILL
XFILL_0__2139_ vdd gnd FILL
X_3954_ _3954_/D _3954_/CLK _3954_/Q vdd gnd DFFPOSX1
X_2767_ _3929_/Q _3927_/Q _2767_/S _2769_/B vdd gnd MUX2X1
X_2698_ _2698_/A _2952_/C _3967_/D vdd gnd AND2X2
XCLKBUF1_insert181 _3822_/Q CLKBUF1_insert181/Y vdd gnd CLKBUF1
X_3319_ _3377_/B _3321_/A _3351_/S _4058_/D vdd gnd MUX2X1
XFILL_0__3042_ vdd gnd FILL
XFILL_0__3111_ vdd gnd FILL
X_3670_ _3671_/Y _3670_/Y vdd gnd INVX1
X_2621_ _3994_/Q _2937_/S _2632_/A _2621_/D _2622_/C vdd gnd AOI22X1
X_2552_ _3977_/Q _2675_/A vdd gnd INVX1
X_2483_ _4053_/Q _2484_/B vdd gnd INVX1
XFILL_0__2757_ vdd gnd FILL
X_3035_ _3035_/A _3035_/B _3062_/C _3795_/D vdd gnd AOI21X1
XFILL_0__2826_ vdd gnd FILL
X_3104_ _3104_/A _3104_/B _3105_/C vdd gnd NAND2X1
X_4084_ _4084_/D _4084_/CLK _4084_/Q vdd gnd DFFPOSX1
X_3937_ _3937_/D _3959_/CLK _3937_/Q vdd gnd DFFPOSX1
XFILL_0__2688_ vdd gnd FILL
X_3799_ _3799_/D _3840_/CLK _3799_/Q vdd gnd DFFPOSX1
X_2819_ _3907_/Q _2939_/A _2820_/C vdd gnd NAND2X1
X_3868_ _3868_/D _4049_/CLK _3868_/Q vdd gnd DFFPOSX1
XFILL_0__2542_ vdd gnd FILL
XFILL_0__2611_ vdd gnd FILL
XFILL_0_CLKBUF1_insert54 vdd gnd FILL
XFILL_0__3591_ vdd gnd FILL
XFILL_0__3660_ vdd gnd FILL
XFILL_0__3025_ vdd gnd FILL
X_2604_ _3015_/C _2618_/B _2637_/A vdd gnd NAND2X1
X_3722_ _3722_/D _3821_/CLK _3722_/Q vdd gnd DFFPOSX1
X_1983_ _4085_/Q _3644_/B vdd gnd INVX1
X_3653_ _3653_/A _3653_/B _3653_/S _3882_/D vdd gnd MUX2X1
X_2535_ _2535_/A _2535_/B _2535_/C _2535_/Y vdd gnd AOI21X1
X_2466_ _2466_/A _2466_/B _2466_/C _2493_/A vdd gnd NAND3X1
X_3584_ _3859_/Q _3587_/C vdd gnd INVX1
X_3018_ _3024_/B _3021_/B vdd gnd INVX1
X_2397_ _3739_/Q _3298_/B vdd gnd INVX1
X_4067_ _4067_/D _4073_/CLK _4067_/Q vdd gnd DFFPOSX1
XFILL128850x28950 vdd gnd FILL
X_2320_ _3999_/Q _3996_/Q _2320_/C _3043_/A vdd gnd OAI21X1
X_2251_ _3465_/A _3551_/A vdd gnd INVX2
XFILL_0__1973_ vdd gnd FILL
XFILL_0__2525_ vdd gnd FILL
XFILL_0__3574_ vdd gnd FILL
X_2182_ _2187_/A _2193_/B _2182_/C _2183_/A vdd gnd OAI21X1
XFILL_0__2387_ vdd gnd FILL
XFILL_0__2456_ vdd gnd FILL
X_1966_ _1966_/A _2134_/B _4091_/D vdd gnd AND2X2
X_3705_ _3705_/A _3705_/B _3806_/Q _3706_/C vdd gnd OAI21X1
X_3567_ _3569_/C _3614_/B _3567_/C _3614_/D _3896_/D vdd gnd OAI22X1
X_1897_ _3721_/Q _3159_/B _2196_/B _1898_/A vdd gnd NAND3X1
X_3636_ _3636_/A _3636_/B _3653_/S _3762_/D vdd gnd MUX2X1
X_2518_ _3773_/Q _3067_/B _2526_/A vdd gnd NOR2X1
X_2449_ _3792_/Q _3384_/C _3106_/C vdd gnd NAND2X1
X_3498_ _3942_/Q _3501_/A vdd gnd INVX1
XFILL_0__2310_ vdd gnd FILL
XFILL_0__3290_ vdd gnd FILL
XFILL_0__2241_ vdd gnd FILL
X_3421_ _3443_/A _3421_/B _3421_/C _3422_/B vdd gnd AOI21X1
X_2303_ _3281_/C _2352_/B _2303_/C _2514_/B vdd gnd AOI21X1
X_3283_ _3305_/A _3305_/B _4070_/Q _3287_/C vdd gnd OAI21X1
X_2234_ _3442_/A _3431_/B _3432_/B _3418_/B vdd gnd NAND3X1
X_3352_ _4022_/Q _3355_/A vdd gnd INVX1
XFILL_0__1956_ vdd gnd FILL
XFILL_0__1887_ vdd gnd FILL
X_2096_ _4059_/Q _3960_/Q _2128_/S _2097_/B vdd gnd MUX2X1
X_2165_ _3743_/Q _3083_/C _2185_/B vdd gnd NOR2X1
X_2998_ _3202_/C _2998_/B _3003_/C _3813_/D vdd gnd AOI21X1
X_1949_ _3649_/B _2193_/B _1949_/C _1950_/A vdd gnd OAI21X1
X_3619_ _3862_/Y _3619_/B _3619_/C _3792_/D vdd gnd OAI21X1
XFILL_0__2790_ vdd gnd FILL
XFILL128550x93750 vdd gnd FILL
X_3970_ _3970_/D _3980_/CLK _3970_/Q vdd gnd DFFPOSX1
X_2783_ _3921_/Q _3919_/Q _2906_/S _2785_/B vdd gnd MUX2X1
X_2921_ _2921_/A _3845_/A _3856_/D vdd gnd AND2X2
X_2852_ _2864_/A _2852_/B _2852_/C _2853_/A vdd gnd OAI21X1
XFILL_0__2155_ vdd gnd FILL
XFILL_0__3273_ vdd gnd FILL
XFILL_0__2086_ vdd gnd FILL
X_3404_ _3404_/A _3404_/B _3552_/A _3404_/Y vdd gnd AOI21X1
X_2217_ _3829_/Q _2218_/B vdd gnd INVX1
X_3197_ _3720_/Q _3199_/A vdd gnd INVX1
X_3266_ _3314_/S _3266_/B _3266_/C _3267_/C vdd gnd OAI21X1
X_3335_ _3335_/A _3337_/A _3377_/S _4041_/D vdd gnd MUX2X1
XFILL_0__3609_ vdd gnd FILL
X_2079_ _4061_/Q _3632_/B vdd gnd INVX1
X_2148_ _2148_/A _2148_/B _2193_/B _2149_/C vdd gnd OAI21X1
XFILL128550x25350 vdd gnd FILL
X_3051_ _3051_/A _3052_/B vdd gnd INVX1
X_3120_ _3120_/A _3295_/A _3611_/B _3121_/C vdd gnd OAI21X1
X_3953_ _3953_/D _3955_/CLK _3953_/Q vdd gnd DFFPOSX1
X_2002_ _4026_/Q _3864_/Q _2090_/S _2003_/B vdd gnd MUX2X1
X_2766_ _2766_/A _2782_/B _3933_/D vdd gnd AND2X2
X_2835_ _3899_/Q _2912_/A _2836_/C vdd gnd NAND2X1
X_2904_ _2908_/A _2904_/B _2904_/C _2905_/A vdd gnd OAI21X1
X_3884_ _3884_/D _4047_/CLK _3884_/Q vdd gnd DFFPOSX1
X_2697_ _2769_/A _2697_/B _2697_/C _2698_/A vdd gnd OAI21X1
X_3318_ _3995_/Q _3377_/B vdd gnd INVX1
XFILL_0__2069_ vdd gnd FILL
XCLKBUF1_insert182 _3822_/Q CLKBUF1_insert182/Y vdd gnd CLKBUF1
X_3249_ _3306_/A _3257_/B _3311_/A vdd gnd AND2X2
X_2620_ _2934_/C _2621_/D vdd gnd INVX1
X_2551_ _3671_/Y _2551_/B _3707_/A _4018_/D vdd gnd AOI21X1
X_2482_ _2482_/A _3623_/C _2492_/B vdd gnd AND2X2
X_3034_ _3795_/Q _3064_/B _3035_/B vdd gnd NAND2X1
X_3103_ _3732_/Q _3743_/Q _3110_/A vdd gnd NOR2X1
X_4083_ _4083_/D _4087_/CLK _4083_/Q vdd gnd DFFPOSX1
XFILL_0__3308_ vdd gnd FILL
X_3936_ _3936_/D _3938_/CLK _3936_/Q vdd gnd DFFPOSX1
XFILL_0__3239_ vdd gnd FILL
X_2749_ _2784_/B _2749_/B _2749_/C _2750_/A vdd gnd OAI21X1
X_2818_ _3905_/Q _3903_/Q _2826_/S _2820_/B vdd gnd MUX2X1
X_3867_ _3867_/D _3893_/CLK _3867_/Q vdd gnd DFFPOSX1
X_3798_ _3910_/R vdd _3798_/D _3940_/CLK _3798_/Q vdd gnd DFFSR
X_1982_ _1982_/A _2189_/C _4087_/D vdd gnd AND2X2
X_2603_ _2603_/A _2603_/B _3015_/B _2618_/B vdd gnd AOI21X1
X_2534_ _3072_/A _2534_/B _2535_/B vdd gnd NAND2X1
X_3583_ _3585_/C _3585_/B _3583_/C _3583_/D _3864_/D vdd gnd OAI22X1
X_3721_ _3721_/D _4016_/CLK _3721_/Q vdd gnd DFFPOSX1
X_3652_ _3652_/A _3652_/B _3712_/S _3886_/D vdd gnd MUX2X1
XFILL_0__2808_ vdd gnd FILL
X_2396_ _3861_/Q _2408_/A vdd gnd INVX1
X_2465_ _3382_/A _2465_/B _3372_/A _3997_/Q _2466_/B vdd gnd AOI22X1
XFILL_0__3857_ vdd gnd FILL
XFILL_0__2739_ vdd gnd FILL
X_3017_ _3025_/A _3017_/B _3805_/D vdd gnd NOR2X1
X_4066_ _4066_/D _4080_/CLK _4066_/Q vdd gnd DFFPOSX1
X_3919_ _3919_/D _3943_/CLK _3919_/Q vdd gnd DFFPOSX1
XFILL129150x75750 vdd gnd FILL
XFILL_0__3711_ vdd gnd FILL
XFILL_0__3642_ vdd gnd FILL
X_2250_ _2286_/C _2259_/B vdd gnd INVX1
X_2181_ _2181_/A _2181_/B _2181_/C _2182_/C vdd gnd OAI21X1
X_3704_ _3846_/Q _3996_/Q _3704_/C _3705_/A vdd gnd NAND3X1
X_1965_ _3647_/B _2053_/B _1965_/C _1966_/A vdd gnd OAI21X1
X_2517_ _2517_/A _3040_/B vdd gnd INVX1
XFILL_0__3007_ vdd gnd FILL
X_3635_ _3635_/A _3635_/B _3653_/S _3764_/D vdd gnd MUX2X1
X_3566_ _3896_/Q _3569_/C vdd gnd INVX1
X_1896_ _1896_/A _3827_/Q _1896_/C _2198_/A vdd gnd NAND3X1
X_3497_ _3497_/A _3497_/B _3549_/S _3944_/D vdd gnd MUX2X1
X_2448_ _3732_/Q _2448_/B _2466_/C vdd gnd NAND2X1
X_2379_ _3743_/Q _3107_/B _2461_/A vdd gnd NOR2X1
X_4049_ _4049_/D _4049_/CLK _4049_/Q vdd gnd DFFPOSX1
X_3420_ _3420_/A _3420_/B _3421_/B vdd gnd NOR2X1
X_3351_ _3351_/A _3353_/A _3351_/S _4024_/D vdd gnd MUX2X1
X_2302_ _2313_/A _2303_/C vdd gnd INVX1
X_3282_ _3282_/A _3282_/B _3316_/A _3282_/D _4072_/D vdd gnd AOI22X1
X_2233_ _3968_/Q _3970_/Q _3432_/B vdd gnd NOR2X1
X_2164_ _3742_/Q _3997_/Q _3393_/B _2166_/B vdd gnd OAI21X1
XFILL_0__2507_ vdd gnd FILL
XFILL_0__2438_ vdd gnd FILL
X_2095_ _4057_/Q _3630_/B vdd gnd INVX1
XFILL_0__3487_ vdd gnd FILL
XFILL_0__3556_ vdd gnd FILL
X_2997_ _2997_/A _3292_/A _3202_/C vdd gnd NAND2X1
X_1879_ _1883_/B _1881_/A vdd gnd INVX1
X_1948_ _1948_/A _1948_/B _2193_/B _1949_/C vdd gnd OAI21X1
X_3618_ _3862_/Y _3618_/B _3619_/C vdd gnd NAND2X1
X_3549_ _3549_/A _3549_/B _3549_/S _3920_/D vdd gnd MUX2X1
XFILL_0_BUFX2_insert107 vdd gnd FILL
X_2920_ _2926_/B _2920_/B _2920_/C _2921_/A vdd gnd OAI21X1
XFILL_0__3341_ vdd gnd FILL
XFILL_0__3410_ vdd gnd FILL
X_2782_ _2782_/A _2782_/B _3925_/D vdd gnd AND2X2
X_2851_ _3891_/Q _2864_/A _2852_/C vdd gnd NAND2X1
XFILL_0__2223_ vdd gnd FILL
XFILL_0__2987_ vdd gnd FILL
X_3334_ _4041_/Q _3337_/A vdd gnd INVX1
X_3403_ _3403_/A _3403_/B _3412_/B _3404_/A vdd gnd OAI21X1
X_2216_ _2343_/A _2343_/B _2529_/A _3066_/B vdd gnd OAI21X1
X_3196_ _3196_/A _3293_/B _3196_/C _3196_/D _3722_/D vdd gnd AOI22X1
X_3265_ _3265_/A _3275_/B _3276_/A _3266_/C vdd gnd NAND3X1
XFILL_0__1869_ vdd gnd FILL
XFILL_0__1938_ vdd gnd FILL
X_2147_ _2198_/C _2147_/B _2148_/B vdd gnd NOR2X1
X_2078_ _2078_/A _2189_/C _4063_/D vdd gnd AND2X2
XFILL_0__2910_ vdd gnd FILL
XFILL_0__2841_ vdd gnd FILL
XFILL_0__2772_ vdd gnd FILL
X_3050_ _3785_/Q _3064_/B _3053_/B vdd gnd NAND2X1
X_2001_ _2169_/A _2001_/B _2004_/A vdd gnd NOR2X1
X_2903_ _3865_/Q _2908_/A _2904_/C vdd gnd NAND2X1
X_3883_ _3883_/D _3889_/CLK _3883_/Q vdd gnd DFFPOSX1
XFILL_0__3255_ vdd gnd FILL
X_3952_ _3952_/D _3954_/CLK _3952_/Q vdd gnd DFFPOSX1
X_2765_ _2769_/A _2765_/B _2765_/C _2766_/A vdd gnd OAI21X1
X_2696_ _3967_/Q _2769_/A _2697_/C vdd gnd NAND2X1
X_2834_ _3897_/Q _3895_/Q _2918_/S _2836_/B vdd gnd MUX2X1
XFILL_0__3186_ vdd gnd FILL
XFILL_0__2137_ vdd gnd FILL
XFILL_0__2206_ vdd gnd FILL
X_3317_ _4058_/Q _3321_/A vdd gnd INVX1
XCLKBUF1_insert150 CLKBUF1_insert184/Y _3964_/CLK vdd gnd CLKBUF1
XCLKBUF1_insert183 _3822_/Q CLKBUF1_insert183/Y vdd gnd CLKBUF1
X_3248_ _4062_/Q _3257_/B _3276_/A _3250_/D vdd gnd OAI21X1
X_3179_ _3179_/A _3666_/Y _3180_/A _3181_/B vdd gnd NAND3X1
XFILL_0__3040_ vdd gnd FILL
X_2550_ _4018_/Q _2550_/B _2551_/B vdd gnd NAND2X1
X_2481_ _3177_/A _2481_/B _2482_/A vdd gnd NAND2X1
XFILL_0__2686_ vdd gnd FILL
XFILL_0__2755_ vdd gnd FILL
X_3033_ _3070_/B _3033_/B _3063_/C _3035_/A vdd gnd NAND3X1
X_4082_ _4082_/D _4084_/CLK _4082_/Q vdd gnd DFFPOSX1
X_3102_ _3752_/Q _3116_/A vdd gnd INVX1
X_3935_ _3935_/D _3959_/CLK _3935_/Q vdd gnd DFFPOSX1
X_3866_ _3866_/A _3866_/B _3866_/Y vdd gnd NOR2X1
X_2679_ _2690_/B _2681_/A vdd gnd INVX1
X_3797_ _3797_/D _3840_/CLK _3797_/Q vdd gnd DFFPOSX1
X_2748_ _3941_/Q _2784_/B _2749_/C vdd gnd NAND2X1
X_2817_ _2937_/S _2931_/B _2817_/Y vdd gnd NOR2X1
XFILL_0__3169_ vdd gnd FILL
XFILL_0__2540_ vdd gnd FILL
XFILL_0__2471_ vdd gnd FILL
X_3720_ _3720_/D _3821_/CLK _3720_/Q vdd gnd DFFPOSX1
X_1981_ _3645_/B _2085_/B _1981_/C _1982_/A vdd gnd OAI21X1
X_2602_ _2602_/A _2602_/B _2603_/A vdd gnd AND2X2
X_2533_ _2533_/A _2533_/B _2533_/C _2534_/B vdd gnd OAI21X1
X_3582_ _3864_/Q _3585_/C vdd gnd INVX1
X_3651_ _3651_/A _3651_/B _3712_/S _3890_/D vdd gnd MUX2X1
X_2464_ _2464_/A _2465_/B vdd gnd INVX1
X_2395_ _3849_/A _2395_/B _2494_/A vdd gnd NAND2X1
X_3016_ _3016_/A _3024_/B _3017_/B vdd gnd NAND2X1
X_4065_ _4065_/D _4087_/CLK _4065_/Q vdd gnd DFFPOSX1
X_3849_ _3849_/A _3849_/Y vdd gnd INVX2
X_3918_ _3918_/D _3997_/CLK _3918_/Q vdd gnd DFFPOSX1
XFILL_0__1971_ vdd gnd FILL
X_2180_ _2185_/B _2472_/B _3084_/S _2181_/C vdd gnd AOI21X1
XFILL_0__2454_ vdd gnd FILL
X_3703_ _3842_/Q _3844_/Q _3704_/C vdd gnd AND2X2
XFILL_0__2385_ vdd gnd FILL
XBUFX2_insert170 _1943_/Y _2053_/B vdd gnd BUFX2
X_1964_ _1964_/A _1964_/B _2053_/B _1965_/C vdd gnd OAI21X1
X_1895_ _1896_/A _1895_/B _1899_/B vdd gnd NAND2X1
X_3634_ _3634_/A _3634_/B _3709_/B _3766_/D vdd gnd MUX2X1
X_2516_ _2516_/A _2516_/B _3051_/A vdd gnd NOR2X1
X_2447_ _3134_/A _2447_/B _3742_/Q _3107_/C _2448_/B vdd gnd OAI22X1
X_3565_ _3567_/C _3614_/B _3565_/C _3614_/D _3900_/D vdd gnd OAI22X1
X_3496_ _3548_/A _3946_/Q _3496_/C _3497_/B vdd gnd OAI21X1
X_2378_ _3177_/A _3138_/A _3107_/B vdd gnd NAND2X1
X_4048_ _4048_/D _4073_/CLK _4048_/Q vdd gnd DFFPOSX1
XFILL_0__2170_ vdd gnd FILL
X_2301_ _3999_/Q _3282_/D _2313_/A vdd gnd NOR2X1
X_3350_ _4024_/Q _3353_/A vdd gnd INVX1
X_3281_ _4074_/Q _3281_/B _3281_/C _3282_/B vdd gnd OAI21X1
X_2232_ _3972_/Q _3442_/A vdd gnd INVX1
XFILL_0__1885_ vdd gnd FILL
X_2163_ _3823_/Q _3393_/B vdd gnd INVX1
XFILL_0__3624_ vdd gnd FILL
X_2094_ _2094_/A _2134_/B _4059_/D vdd gnd AND2X2
XFILL_0__2299_ vdd gnd FILL
X_2996_ _3640_/A _3640_/B _3624_/A _2997_/A vdd gnd MUX2X1
X_3617_ _3617_/A _3617_/B _3617_/C _4053_/D vdd gnd AOI21X1
X_1947_ _2083_/A _1947_/B _1948_/B vdd gnd NOR2X1
X_1878_ _3723_/Q _3158_/B _1883_/B vdd gnd NOR2X1
X_3548_ _3548_/A _3968_/Q _3548_/C _3549_/B vdd gnd OAI21X1
X_3479_ _3521_/A _3640_/B _3480_/C vdd gnd NAND2X1
X_2850_ _3889_/Q _3887_/Q _2918_/S _2852_/B vdd gnd MUX2X1
X_2781_ _2784_/B _2781_/B _2781_/C _2782_/A vdd gnd OAI21X1
XFILL_0__2084_ vdd gnd FILL
XFILL_0__2153_ vdd gnd FILL
X_3264_ _3645_/A _3645_/B _3708_/A _3266_/B vdd gnd MUX2X1
X_3333_ _3333_/A _3335_/A _3365_/S _4043_/D vdd gnd MUX2X1
X_3402_ _3402_/A _3404_/B vdd gnd INVX1
X_2215_ _3984_/Q _2343_/B vdd gnd INVX1
X_3195_ _3724_/Q _3213_/B _3213_/C _3196_/D vdd gnd OAI21X1
X_2077_ _3633_/B _2085_/B _2077_/C _2078_/A vdd gnd OAI21X1
XFILL_0__3607_ vdd gnd FILL
XFILL_0__3538_ vdd gnd FILL
X_2146_ _3989_/Q _3767_/Q _2146_/S _2147_/B vdd gnd MUX2X1
X_2979_ _3009_/A _3004_/B _3819_/Q _2983_/B vdd gnd OAI21X1
XFILL128250x75750 vdd gnd FILL
X_2000_ _4083_/Q _3936_/Q _2191_/S _2001_/B vdd gnd MUX2X1
X_3951_ _3951_/D _3955_/CLK _3951_/Q vdd gnd DFFPOSX1
X_2833_ _2833_/A _2913_/B _3901_/D vdd gnd AND2X2
X_2902_ _3863_/Q _3860_/Q _2906_/S _2904_/B vdd gnd MUX2X1
XFILL_0__3323_ vdd gnd FILL
X_3882_ _3910_/R vdd _3882_/D _3940_/CLK _3882_/Q vdd gnd DFFSR
X_2764_ _3933_/Q _2769_/A _2765_/C vdd gnd NAND2X1
X_2695_ _3965_/Q _3963_/Q _2767_/S _2697_/B vdd gnd MUX2X1
XFILL_0__2969_ vdd gnd FILL
XCLKBUF1_insert140 CLKBUF1_insert185/Y _3900_/CLK vdd gnd CLKBUF1
X_3247_ _3247_/A _3247_/B _3862_/Y _3257_/B vdd gnd OAI21X1
X_3316_ _3316_/A _3316_/B _3316_/C _4060_/D vdd gnd OAI21X1
XCLKBUF1_insert151 CLKBUF1_insert183/Y _4008_/CLK vdd gnd CLKBUF1
XCLKBUF1_insert184 _3822_/Q CLKBUF1_insert184/Y vdd gnd CLKBUF1
X_3178_ _3178_/A _3290_/B _3258_/C _3731_/D vdd gnd OAI21X1
X_2129_ _2129_/A _2129_/B _2132_/A vdd gnd NOR2X1
XFILL128850x54150 vdd gnd FILL
X_2480_ _3623_/A _3623_/B _2481_/B vdd gnd NOR2X1
XFILL_0__2823_ vdd gnd FILL
X_3101_ _3165_/C _3866_/A _3753_/D vdd gnd AND2X2
X_4081_ _4081_/D _4087_/CLK _4081_/Q vdd gnd DFFPOSX1
X_3032_ _3032_/A _3032_/B _3032_/C _3797_/D vdd gnd AOI21X1
X_2816_ _2816_/A _2952_/C _3909_/D vdd gnd AND2X2
X_3865_ _3865_/D _3893_/CLK _3865_/Q vdd gnd DFFPOSX1
XFILL_0__3306_ vdd gnd FILL
X_3796_ _3796_/D _3900_/CLK _3796_/Q vdd gnd DFFPOSX1
XFILL_0__2119_ vdd gnd FILL
X_3934_ _3934_/D _3954_/CLK _3934_/Q vdd gnd DFFPOSX1
XFILL_0__3237_ vdd gnd FILL
X_2747_ _3939_/Q _3937_/Q _2751_/S _2749_/B vdd gnd MUX2X1
X_2678_ _2678_/A _3976_/D vdd gnd INVX1
XFILL_0__3022_ vdd gnd FILL
X_1980_ _1980_/A _1980_/B _2045_/B _1981_/C vdd gnd OAI21X1
X_3650_ _3650_/A _3650_/B _3650_/S _3894_/D vdd gnd MUX2X1
X_2601_ _3805_/Q _4014_/Q _2602_/B vdd gnd NOR2X1
X_2532_ _2532_/A _2532_/B _3071_/B _2533_/C vdd gnd OAI21X1
X_2463_ _3788_/Q _2463_/B _2464_/A vdd gnd NAND2X1
X_3581_ _3583_/C _3585_/B _3581_/C _3583_/D _3868_/D vdd gnd OAI22X1
XFILL_0__2737_ vdd gnd FILL
X_3015_ _4014_/Q _3015_/B _3015_/C _3016_/A vdd gnd OAI21X1
XFILL_0__2806_ vdd gnd FILL
X_2394_ _2503_/B _2498_/B vdd gnd INVX1
X_4064_ _4064_/D _4084_/CLK _4064_/Q vdd gnd DFFPOSX1
XFILL_0__2668_ vdd gnd FILL
XFILL129150x10950 vdd gnd FILL
X_3779_ _3779_/D _3837_/CLK _3779_/Q vdd gnd DFFPOSX1
X_3917_ _3917_/D _3917_/CLK _3917_/Q vdd gnd DFFPOSX1
X_3848_ _3848_/D _4100_/CLK _3848_/Q vdd gnd DFFPOSX1
XFILL_0__3640_ vdd gnd FILL
XFILL_0__3571_ vdd gnd FILL
XFILL_0__2522_ vdd gnd FILL
XBUFX2_insert160 _2694_/Y _2741_/A vdd gnd BUFX2
XFILL_0__3005_ vdd gnd FILL
X_1963_ _2123_/A _1963_/B _1964_/B vdd gnd NOR2X1
XBUFX2_insert171 _1943_/Y _2085_/B vdd gnd BUFX2
X_1894_ _1895_/B _1894_/B _1894_/C _1900_/A vdd gnd AOI21X1
X_3702_ _3765_/Q _4032_/Q _3702_/Y vdd gnd NOR2X1
X_3633_ _3633_/A _3633_/B _3709_/B _3768_/D vdd gnd MUX2X1
X_2515_ _2515_/A _3048_/B vdd gnd INVX1
X_2446_ _2446_/A _2447_/B _3107_/C vdd gnd NAND2X1
X_3564_ _3900_/Q _3567_/C vdd gnd INVX1
X_3495_ _3548_/A _3644_/B _3496_/C vdd gnd NAND2X1
X_2377_ _3742_/Q _3138_/A vdd gnd INVX2
X_4047_ _4047_/D _4047_/CLK _4047_/Q vdd gnd DFFPOSX1
X_2300_ _2529_/A _2300_/B _2514_/A vdd gnd NOR2X1
X_3280_ _3295_/B _3698_/B _3282_/A vdd gnd NAND2X1
XFILL_0__1953_ vdd gnd FILL
X_2231_ _2244_/A _2231_/B _2412_/A _3413_/B vdd gnd NAND3X1
XFILL_0__2505_ vdd gnd FILL
X_2093_ _3631_/B _2133_/B _2093_/C _2094_/A vdd gnd OAI21X1
XFILL_0__3554_ vdd gnd FILL
X_2162_ _2162_/A _2189_/C _4042_/D vdd gnd AND2X2
XFILL_0__2367_ vdd gnd FILL
XFILL_0__2436_ vdd gnd FILL
X_2995_ _3746_/Q _3640_/A vdd gnd INVX1
XFILL_0__3485_ vdd gnd FILL
X_3616_ _3616_/A _3617_/B vdd gnd INVX1
X_1877_ _3158_/B _1877_/B _3668_/Y _3725_/D vdd gnd AOI21X1
X_1946_ _4008_/Q _3835_/Q _2130_/S _1947_/B vdd gnd MUX2X1
X_3547_ _3548_/A _3632_/B _3548_/C vdd gnd NAND2X1
X_3478_ _3952_/Q _3481_/A vdd gnd INVX1
X_2429_ _3756_/Q _3754_/Q _3412_/A vdd gnd NOR2X1
XFILL_0_BUFX2_insert109 vdd gnd FILL
XFILL_0__3270_ vdd gnd FILL
XFILL_0__2221_ vdd gnd FILL
X_2780_ _3925_/Q _2792_/B _2781_/C vdd gnd NAND2X1
X_3401_ _3401_/A _3401_/B _3862_/Y _3402_/A vdd gnd OAI21X1
X_2214_ _4025_/Q _2343_/A vdd gnd INVX1
X_3194_ _3722_/Q _3196_/A vdd gnd INVX1
X_3263_ _3914_/Q _3645_/A vdd gnd INVX1
XFILL_0__1867_ vdd gnd FILL
X_3332_ _4043_/Q _3335_/A vdd gnd INVX1
XFILL_0__1936_ vdd gnd FILL
XFILL_0__2985_ vdd gnd FILL
X_2076_ _2076_/A _2076_/B _2085_/B _2077_/C vdd gnd OAI21X1
X_2145_ _2169_/A _2145_/B _2148_/A vdd gnd NOR2X1
X_2978_ _3258_/C _2978_/B _3013_/C _3821_/D vdd gnd AOI21X1
X_1929_ _2198_/C _1929_/B _1929_/C _1930_/B vdd gnd OAI21X1
XFILL_0__3399_ vdd gnd FILL
XFILL_0__2770_ vdd gnd FILL
XFILL129150x115350 vdd gnd FILL
X_3950_ _3950_/D _3964_/CLK _3950_/Q vdd gnd DFFPOSX1
X_2763_ _3931_/Q _3929_/Q _2767_/S _2765_/B vdd gnd MUX2X1
X_2832_ _2912_/A _2832_/B _2832_/C _2833_/A vdd gnd OAI21X1
X_2901_ _2901_/A _2917_/B _3867_/D vdd gnd AND2X2
XFILL_0__3253_ vdd gnd FILL
X_3881_ _3881_/D _3889_/CLK _3881_/Q vdd gnd DFFPOSX1
XFILL_0__2204_ vdd gnd FILL
XFILL_0__2135_ vdd gnd FILL
XFILL_0__3184_ vdd gnd FILL
X_2694_ _2813_/S _2811_/B _2694_/Y vdd gnd NOR2X1
XFILL_0__2066_ vdd gnd FILL
XCLKBUF1_insert130 CLKBUF1_insert181/Y _3986_/CLK vdd gnd CLKBUF1
XFILL_0__2899_ vdd gnd FILL
XCLKBUF1_insert141 CLKBUF1_insert180/Y _4080_/CLK vdd gnd CLKBUF1
X_3177_ _3177_/A _3290_/B _3205_/C _3732_/D vdd gnd OAI21X1
X_3246_ _3246_/A _3247_/B vdd gnd INVX1
X_3315_ _4060_/Q _3316_/A _3316_/C vdd gnd NAND2X1
XCLKBUF1_insert185 _3822_/Q CLKBUF1_insert185/Y vdd gnd CLKBUF1
XCLKBUF1_insert152 CLKBUF1_insert184/Y _4090_/CLK vdd gnd CLKBUF1
X_2128_ _4050_/Q _3920_/Q _2128_/S _2129_/B vdd gnd MUX2X1
X_2059_ _2177_/C _2059_/B _2060_/B vdd gnd NOR2X1
XFILL_0__2684_ vdd gnd FILL
X_3031_ _3797_/Q _3031_/B _3031_/C _3032_/C vdd gnd OAI21X1
X_4080_ _4080_/D _4080_/CLK _4080_/Q vdd gnd DFFPOSX1
X_3100_ _3117_/A _3117_/B _3120_/A _3754_/D vdd gnd AOI21X1
X_3933_ _3933_/D _3959_/CLK _3933_/Q vdd gnd DFFPOSX1
X_3795_ _3795_/D _4021_/CLK _3795_/Q vdd gnd DFFPOSX1
X_2815_ _2815_/A _2815_/B _2815_/C _2816_/A vdd gnd OAI21X1
X_2746_ _2746_/A _2917_/B _3943_/D vdd gnd AND2X2
XFILL_0__3098_ vdd gnd FILL
X_3864_ _3864_/D _4049_/CLK _3864_/Q vdd gnd DFFPOSX1
X_2677_ _2677_/A _2677_/B _2677_/C _2678_/A vdd gnd NAND3X1
XFILL_0__2049_ vdd gnd FILL
X_3229_ _3308_/B _3229_/B _3229_/C _4094_/D vdd gnd AOI21X1
XFILL_0_CLKBUF1_insert47 vdd gnd FILL
X_2600_ _3801_/Q _3803_/Q _2602_/A vdd gnd NOR2X1
X_3580_ _3868_/Q _3583_/C vdd gnd INVX1
X_2531_ _2665_/B _2608_/A _2606_/A _2537_/A _2532_/A vdd gnd OAI22X1
X_2393_ _2393_/A _2593_/C _2593_/B _2503_/B vdd gnd AOI21X1
X_2462_ _2462_/A _3382_/A vdd gnd INVX1
X_3014_ _3805_/Q _3014_/B _3024_/B vdd gnd NAND2X1
X_4063_ _4063_/D _4087_/CLK _4063_/Q vdd gnd DFFPOSX1
XFILL_0__2598_ vdd gnd FILL
XFILL_0__3219_ vdd gnd FILL
X_3916_ _3916_/D _3916_/CLK _3916_/Q vdd gnd DFFPOSX1
X_2729_ _2741_/A _2729_/B _2729_/C _2730_/A vdd gnd OAI21X1
X_3847_ _3847_/D _3900_/CLK _3847_/Q vdd gnd DFFPOSX1
X_3778_ _3910_/R vdd _3778_/D _4090_/CLK _3778_/Q vdd gnd DFFSR
XFILL_0__2383_ vdd gnd FILL
X_1962_ _4013_/Q _3843_/Q _2130_/S _1963_/B vdd gnd MUX2X1
XBUFX2_insert161 _2694_/Y _2801_/A vdd gnd BUFX2
X_3632_ _3632_/A _3632_/B _3709_/B _3770_/D vdd gnd MUX2X1
XBUFX2_insert172 _1943_/Y _2045_/B vdd gnd BUFX2
X_3563_ _3565_/C _3609_/B _3563_/C _3609_/D _3904_/D vdd gnd OAI22X1
X_1893_ _3827_/Q _1896_/A _1894_/B vdd gnd NOR2X1
X_3701_ _3702_/Y _3701_/Y vdd gnd INVX1
X_2514_ _2514_/A _2514_/B _2515_/A vdd gnd NOR2X1
X_2445_ _2451_/A _2934_/B _2456_/B _2446_/A vdd gnd OAI21X1
X_2376_ _3818_/Q _3698_/A vdd gnd INVX1
X_3494_ _3944_/Q _3497_/A vdd gnd INVX1
XFILL_0__2719_ vdd gnd FILL
X_4046_ _4046_/D _4087_/CLK _4046_/Q vdd gnd DFFPOSX1
XFILL_0__1883_ vdd gnd FILL
XFILL_0__3622_ vdd gnd FILL
X_2230_ _3754_/Q _3732_/Q _2230_/C _2231_/B vdd gnd NAND3X1
X_2092_ _2092_/A _2092_/B _2133_/B _2093_/C vdd gnd OAI21X1
X_2161_ _2168_/A _2161_/B _2161_/C _2162_/A vdd gnd OAI21X1
XFILL_0__2297_ vdd gnd FILL
X_2994_ _2999_/A _3009_/B _3813_/Q _2998_/B vdd gnd OAI21X1
X_1945_ _3083_/A _1945_/B _1948_/A vdd gnd NOR2X1
X_3615_ _3615_/A _3615_/B _3617_/C _3861_/D vdd gnd AOI21X1
X_1876_ _3727_/Q _1876_/B _3725_/Q _1877_/B vdd gnd OAI21X1
X_3546_ _3920_/Q _3549_/A vdd gnd INVX1
X_2359_ _2359_/A _2359_/B _2359_/C _3066_/A vdd gnd NAND3X1
X_2428_ _3615_/B _2433_/A _2428_/C _3615_/A vdd gnd NAND3X1
X_3477_ _3477_/A _3477_/B _3522_/S _3954_/D vdd gnd MUX2X1
X_4029_ _4029_/D _4035_/CLK _4029_/Q vdd gnd DFFPOSX1
XFILL128850x39750 vdd gnd FILL
XFILL128850x82950 vdd gnd FILL
X_3331_ _3331_/A _3333_/A _3365_/S _4045_/D vdd gnd MUX2X1
XFILL_0__2082_ vdd gnd FILL
X_3400_ _3756_/Q _3997_/Q _3754_/Q _3823_/Q _3401_/B vdd gnd AOI22X1
X_2213_ _3999_/Q _2529_/A vdd gnd INVX2
X_3193_ _3193_/A _3293_/B _3193_/C _3193_/D _3724_/D vdd gnd AOI22X1
X_3262_ _3275_/B _3262_/B _3316_/A vdd gnd NOR2X1
X_2144_ _4046_/Q _3970_/Q _2191_/S _2145_/B vdd gnd MUX2X1
XFILL_0__3605_ vdd gnd FILL
XFILL_0__2418_ vdd gnd FILL
XFILL_0__3467_ vdd gnd FILL
XFILL_0__3536_ vdd gnd FILL
X_2075_ _2083_/A _2075_/B _2076_/B vdd gnd NOR2X1
X_2977_ _2977_/A _3292_/A _3258_/C vdd gnd NAND2X1
X_1928_ _3715_/Q _1938_/B _3082_/S _1929_/C vdd gnd NAND3X1
X_3529_ _3540_/A _3652_/B _3530_/C vdd gnd NAND2X1
X_2900_ _2908_/A _2900_/B _2900_/C _2901_/A vdd gnd OAI21X1
XFILL_0__3321_ vdd gnd FILL
X_2762_ _2762_/A _2913_/B _3935_/D vdd gnd AND2X2
X_2831_ _3901_/Q _2912_/A _2832_/C vdd gnd NAND2X1
X_3880_ _3880_/D _3916_/CLK _3880_/Q vdd gnd DFFPOSX1
X_2693_ _2693_/A _2693_/B _3969_/D vdd gnd NOR2X1
XFILL_0__2967_ vdd gnd FILL
XCLKBUF1_insert120 CLKBUF1_insert180/Y _4098_/CLK vdd gnd CLKBUF1
X_3314_ _4088_/Q _3314_/B _3314_/S _3316_/B vdd gnd MUX2X1
XCLKBUF1_insert142 CLKBUF1_insert185/Y _4045_/CLK vdd gnd CLKBUF1
XCLKBUF1_insert131 CLKBUF1_insert185/Y _3916_/CLK vdd gnd CLKBUF1
XCLKBUF1_insert153 CLKBUF1_insert181/Y _3907_/CLK vdd gnd CLKBUF1
X_3176_ _3306_/A _3691_/D _3205_/C vdd gnd OR2X2
X_3245_ _4086_/Q _3250_/A vdd gnd INVX1
X_2127_ _4048_/Q _3626_/B vdd gnd INVX1
XFILL_0__1918_ vdd gnd FILL
X_2058_ _4041_/Q _3892_/Q _2082_/S _2059_/B vdd gnd MUX2X1
XFILL_0__2821_ vdd gnd FILL
X_3030_ _3030_/A _3031_/B _3799_/D vdd gnd NOR2X1
XFILL_0__2752_ vdd gnd FILL
X_3863_ _3863_/D _3893_/CLK _3863_/Q vdd gnd DFFPOSX1
XFILL_0__3304_ vdd gnd FILL
XFILL_0__3235_ vdd gnd FILL
X_3932_ _3932_/D _3940_/CLK _3932_/Q vdd gnd DFFPOSX1
X_2814_ _3909_/Q _2815_/A _2815_/C vdd gnd NAND2X1
X_2745_ _2792_/B _2745_/B _2745_/C _2746_/A vdd gnd OAI21X1
X_2676_ _3976_/Q _2676_/B _2677_/B vdd gnd NAND2X1
X_3794_ _3794_/D _3837_/CLK _3794_/Q vdd gnd DFFPOSX1
XFILL_0__2117_ vdd gnd FILL
XFILL_0__3166_ vdd gnd FILL
X_3228_ _4094_/Q _3308_/B _3229_/C vdd gnd NOR2X1
X_3159_ _3159_/A _3159_/B _3670_/Y _3160_/A vdd gnd AOI21X1
XFILL_0__3020_ vdd gnd FILL
X_2530_ _3069_/B _2665_/B vdd gnd INVX1
X_2392_ _2392_/A _2593_/C vdd gnd INVX1
X_2461_ _2461_/A _3104_/A _3104_/B _2466_/A vdd gnd NAND3X1
XFILL_0__2735_ vdd gnd FILL
XFILL_0__2666_ vdd gnd FILL
X_3013_ _3193_/C _3013_/B _3013_/C _3807_/D vdd gnd AOI21X1
X_4062_ _4062_/D _3700_/A _4062_/Q vdd gnd DFFPOSX1
X_3846_ _3846_/D _3996_/CLK _3846_/Q vdd gnd DFFPOSX1
X_3915_ _3915_/D _3917_/CLK _3915_/Q vdd gnd DFFPOSX1
X_2728_ _3951_/Q _2741_/A _2729_/C vdd gnd NAND2X1
X_3777_ _3777_/D _4021_/CLK _3777_/Q vdd gnd DFFPOSX1
X_2659_ _2659_/A _2659_/B _2659_/C _3986_/D vdd gnd AOI21X1
XFILL_0__3149_ vdd gnd FILL
XFILL_0__2520_ vdd gnd FILL
XFILL_0__2451_ vdd gnd FILL
XFILL_0__3003_ vdd gnd FILL
X_3700_ _3700_/A _3700_/Y vdd gnd INVX1
X_1961_ _2049_/A _1961_/B _1964_/A vdd gnd NOR2X1
X_1892_ _1907_/B _1895_/B vdd gnd INVX1
X_2513_ _2513_/A _2513_/B _3072_/A vdd gnd NAND2X1
XBUFX2_insert162 _2694_/Y _2815_/A vdd gnd BUFX2
XBUFX2_insert173 _2817_/Y _2912_/A vdd gnd BUFX2
X_3562_ _3904_/Q _3565_/C vdd gnd INVX1
X_3493_ _3493_/A _3493_/B _3531_/S _3946_/D vdd gnd MUX2X1
X_3631_ _3631_/A _3631_/B _3646_/S _3772_/D vdd gnd MUX2X1
X_2375_ _3003_/C _2375_/B _4025_/D vdd gnd NOR2X1
X_2444_ _3741_/Q _3383_/A _2457_/A _2456_/B vdd gnd OAI21X1
XFILL_0__3698_ vdd gnd FILL
X_4045_ _4045_/D _4045_/CLK _4045_/Q vdd gnd DFFPOSX1
X_3829_ _3829_/D _4009_/CLK _3829_/Q vdd gnd DFFPOSX1
XFILL128550x115350 vdd gnd FILL
XFILL_0__1951_ vdd gnd FILL
X_2160_ _2160_/A _2160_/B _2161_/B _2161_/C vdd gnd NAND3X1
XFILL_0__2434_ vdd gnd FILL
X_2091_ _2177_/C _2091_/B _2092_/B vdd gnd NOR2X1
XFILL_0__3483_ vdd gnd FILL
X_1875_ _1875_/A _1875_/B _3158_/B vdd gnd NAND2X1
XFILL_0__2365_ vdd gnd FILL
X_2993_ _3250_/C _2993_/B _3013_/C _3815_/D vdd gnd AOI21X1
X_3614_ _3614_/A _3614_/B _3614_/C _3614_/D _3830_/D vdd gnd OAI22X1
X_1944_ _4097_/Q _3922_/Q _2191_/S _1945_/B vdd gnd MUX2X1
X_2427_ _2434_/B _2434_/C _2428_/C vdd gnd NAND2X1
X_3476_ _3525_/A _3956_/Q _3476_/C _3477_/B vdd gnd OAI21X1
X_3545_ _3545_/A _3545_/B _3545_/S _3922_/D vdd gnd MUX2X1
X_4028_ _4028_/D _2373_/A _4028_/Q vdd gnd DFFPOSX1
X_2358_ _2358_/A _2358_/B _2359_/B vdd gnd NOR2X1
X_2289_ _2289_/A _2289_/B _2289_/C _2289_/Y vdd gnd NAND3X1
XFILL129150x86550 vdd gnd FILL
XFILL_0__2150_ vdd gnd FILL
XFILL_0__2983_ vdd gnd FILL
X_3330_ _4045_/Q _3333_/A vdd gnd INVX1
X_2212_ _4027_/Q _2513_/B _3070_/B vdd gnd NOR2X1
X_3192_ _3213_/C _3213_/B _3293_/B vdd gnd AND2X2
X_3261_ _3281_/B _3275_/B vdd gnd INVX1
XFILL_0__1865_ vdd gnd FILL
XFILL_0__1934_ vdd gnd FILL
X_2143_ _4044_/Q _3712_/B vdd gnd INVX1
X_2074_ _4045_/Q _3900_/Q _2082_/S _2075_/B vdd gnd MUX2X1
XFILL_0__3397_ vdd gnd FILL
XFILL_0__2279_ vdd gnd FILL
X_2976_ _3635_/A _3635_/B _3624_/A _2977_/A vdd gnd MUX2X1
XFILL129150x18150 vdd gnd FILL
X_1927_ _4002_/Q _3820_/Q _2146_/S _1929_/B vdd gnd MUX2X1
X_3459_ _3962_/Q _3462_/A vdd gnd INVX1
X_3528_ _3713_/Q _3652_/B vdd gnd INVX1
X_2830_ _3899_/Q _3897_/Q _2918_/S _2832_/B vdd gnd MUX2X1
XFILL_0__3182_ vdd gnd FILL
X_2692_ _3969_/Q _2692_/B _2952_/C _2693_/A vdd gnd OAI21X1
X_2761_ _2773_/A _2761_/B _2761_/C _2762_/A vdd gnd OAI21X1
XFILL_0__2133_ vdd gnd FILL
XFILL_0__2064_ vdd gnd FILL
XCLKBUF1_insert143 CLKBUF1_insert181/Y _3955_/CLK vdd gnd CLKBUF1
XCLKBUF1_insert121 CLKBUF1_insert182/Y _4025_/CLK vdd gnd CLKBUF1
XCLKBUF1_insert154 CLKBUF1_insert180/Y _3700_/A vdd gnd CLKBUF1
X_3244_ _3308_/B _3244_/B _3244_/C _4088_/D vdd gnd AOI21X1
X_3313_ _3644_/A _3644_/B _3313_/S _3314_/B vdd gnd MUX2X1
XCLKBUF1_insert132 CLKBUF1_insert184/Y _3954_/CLK vdd gnd CLKBUF1
X_2126_ _2126_/A _2134_/B _4050_/D vdd gnd AND2X2
X_2057_ _2081_/A _2057_/B _2060_/A vdd gnd NOR2X1
XFILL_0__3518_ vdd gnd FILL
X_3175_ _4079_/Q _3185_/B _3175_/C _3691_/D vdd gnd OAI21X1
X_2959_ _3821_/Q _3813_/Q _3805_/Q _2961_/B vdd gnd MUX2X1
XFILL_0__2682_ vdd gnd FILL
X_3931_ _3931_/D _3986_/CLK _3931_/Q vdd gnd DFFPOSX1
X_2813_ _4001_/Q _3992_/Q _2813_/S _2815_/B vdd gnd MUX2X1
X_3862_ _3870_/Y _3866_/Y _3862_/Y vdd gnd NAND2X1
X_3793_ _3793_/D _4021_/CLK _3793_/Q vdd gnd DFFPOSX1
X_2744_ _3943_/Q _2792_/B _2745_/C vdd gnd NAND2X1
X_2675_ _2675_/A _2675_/B _2675_/C _2677_/A vdd gnd OAI21X1
XFILL_0__3096_ vdd gnd FILL
XFILL_0__2949_ vdd gnd FILL
X_3227_ _4096_/Q _3227_/B _3314_/S _3229_/B vdd gnd MUX2X1
X_3089_ _3165_/C _3870_/A _3758_/D vdd gnd AND2X2
X_2109_ _3629_/B _2125_/B _2109_/C _2110_/A vdd gnd OAI21X1
X_3158_ _3158_/A _3158_/B _3159_/A vdd gnd NOR2X1
XFILL_0_CLKBUF1_insert49 vdd gnd FILL
XFILL128250x126150 vdd gnd FILL
X_2460_ _3106_/A _3106_/B _3104_/B vdd gnd NAND2X1
XFILL_0__2803_ vdd gnd FILL
X_2391_ _4005_/Q _2391_/B _2392_/A vdd gnd NAND2X1
X_4061_ _4061_/D _4073_/CLK _4061_/Q vdd gnd DFFPOSX1
X_3012_ _3012_/A _3292_/A _3193_/C vdd gnd NAND2X1
X_3914_ _3914_/R vdd _3914_/D _4092_/CLK _3914_/Q vdd gnd DFFSR
XFILL_0__3217_ vdd gnd FILL
X_3776_ _3910_/R vdd _3776_/D _4090_/CLK _3776_/Q vdd gnd DFFSR
X_3845_ _3845_/A _3853_/Y _3849_/Y _3845_/Y vdd gnd NAND3X1
X_2727_ _3949_/Q _3947_/Q _2751_/S _2729_/B vdd gnd MUX2X1
X_2658_ _3986_/Q _2658_/B _2952_/C _2659_/C vdd gnd OAI21X1
X_2589_ _2589_/A _3705_/B vdd gnd INVX1
XFILL_0__2381_ vdd gnd FILL
XBUFX2_insert163 _2694_/Y _2773_/A vdd gnd BUFX2
XBUFX2_insert174 _2817_/Y _2939_/A vdd gnd BUFX2
X_1960_ _4093_/Q _3926_/Q _2187_/S _1961_/B vdd gnd MUX2X1
X_1891_ _2196_/B _1896_/C _1907_/B vdd gnd NAND2X1
X_3630_ _3630_/A _3630_/B _3653_/S _3774_/D vdd gnd MUX2X1
X_2512_ _3771_/Q _2529_/B _3769_/Q _2513_/A vdd gnd OAI21X1
X_2443_ _3384_/C _3551_/B _2447_/B vdd gnd NAND2X1
X_3561_ _3563_/C _3609_/B _3561_/C _3609_/D _3908_/D vdd gnd OAI22X1
X_3492_ _3525_/A _3948_/Q _3492_/C _3493_/B vdd gnd OAI21X1
XFILL_0__2717_ vdd gnd FILL
X_2374_ _4025_/Q _2374_/B _2590_/A _2375_/B vdd gnd MUX2X1
X_4044_ _4044_/D _4087_/CLK _4044_/Q vdd gnd DFFPOSX1
XFILL_0__2648_ vdd gnd FILL
X_3828_ _3828_/D _3837_/CLK _3828_/Q vdd gnd DFFPOSX1
X_3759_ _3759_/D _3885_/CLK _3866_/A vdd gnd DFFPOSX1
XFILL_0__3620_ vdd gnd FILL
X_2090_ _4049_/Q _3908_/Q _2090_/S _2091_/B vdd gnd MUX2X1
XFILL_0__3551_ vdd gnd FILL
XFILL_0__2502_ vdd gnd FILL
X_2992_ _2992_/A _3262_/B _3250_/C vdd gnd NAND2X1
X_1874_ _3727_/Q _1876_/B _1875_/B vdd gnd NOR2X1
X_3613_ _3614_/C _3613_/B _3613_/C _3613_/D _3796_/D vdd gnd OAI22X1
XFILL129150x7350 vdd gnd FILL
X_1943_ _3084_/S _1943_/Y vdd gnd INVX8
X_2426_ _2426_/A _2426_/B _3383_/A _2434_/B vdd gnd NAND3X1
X_3475_ _3525_/A _3639_/B _3476_/C vdd gnd NAND2X1
X_3544_ _3552_/A _3924_/Q _3544_/C _3545_/B vdd gnd OAI21X1
X_4027_ _4027_/D _2373_/A _4027_/Q vdd gnd DFFPOSX1
X_2357_ _2357_/A _2357_/B _2358_/B vdd gnd NAND2X1
X_2288_ _2999_/A _2289_/B vdd gnd INVX1
XFILL_0__2080_ vdd gnd FILL
X_3260_ _3862_/Y _3260_/B _3281_/B vdd gnd NAND2X1
X_2211_ _2371_/B _2505_/A _2513_/B vdd gnd NAND2X1
X_3191_ _4068_/Q _3213_/B _3289_/C _3193_/D vdd gnd OAI21X1
XFILL_0__3534_ vdd gnd FILL
X_2073_ _2081_/A _2073_/B _2076_/A vdd gnd NOR2X1
X_2142_ _2142_/A _3906_/R _4046_/D vdd gnd AND2X2
XFILL_0__2347_ vdd gnd FILL
XFILL_0__2416_ vdd gnd FILL
X_2975_ _3764_/Q _3635_/A vdd gnd INVX1
XFILL_0__3465_ vdd gnd FILL
X_3527_ _3928_/Q _3531_/A vdd gnd INVX1
X_1926_ _2195_/C _1926_/B _3715_/D vdd gnd NOR2X1
X_3389_ _3390_/A _3390_/B _3394_/A vdd gnd OR2X2
X_3458_ _3458_/A _3458_/B _3531_/S _3964_/D vdd gnd MUX2X1
X_2409_ _3177_/A _3414_/A _2410_/C vdd gnd NAND2X1
XFILL_0__3250_ vdd gnd FILL
XFILL_0__2201_ vdd gnd FILL
X_2691_ _2691_/A _2692_/B vdd gnd INVX1
X_2760_ _3935_/Q _2773_/A _2761_/C vdd gnd NAND2X1
XCLKBUF1_insert155 CLKBUF1_insert182/Y _4014_/CLK vdd gnd CLKBUF1
XFILL_0__2896_ vdd gnd FILL
XFILL_0__2965_ vdd gnd FILL
XCLKBUF1_insert122 CLKBUF1_insert180/Y _3685_/A vdd gnd CLKBUF1
X_3243_ _4088_/Q _3308_/B _3244_/C vdd gnd NOR2X1
XCLKBUF1_insert144 CLKBUF1_insert183/Y _4053_/CLK vdd gnd CLKBUF1
XCLKBUF1_insert133 CLKBUF1_insert185/Y _4047_/CLK vdd gnd CLKBUF1
XFILL_0__1916_ vdd gnd FILL
X_3312_ _3728_/Q _3644_/A vdd gnd INVX1
X_2125_ _3627_/B _2125_/B _2125_/C _2126_/A vdd gnd OAI21X1
X_2056_ _4069_/Q _3950_/Q _2064_/S _2057_/B vdd gnd MUX2X1
X_3174_ _3185_/B _3641_/A _3175_/C vdd gnd NAND2X1
X_2958_ _2958_/A _2958_/B _3003_/C _3834_/D vdd gnd AOI21X1
XFILL_0__3379_ vdd gnd FILL
X_1909_ _3761_/Q _1910_/B vdd gnd INVX1
X_2889_ _2889_/A _2917_/B _3873_/D vdd gnd AND2X2
XFILL_0__2750_ vdd gnd FILL
X_3930_ _3930_/D _4035_/CLK _3930_/Q vdd gnd DFFPOSX1
X_2743_ _3941_/Q _3939_/Q _2751_/S _2745_/B vdd gnd MUX2X1
X_2812_ _2812_/A _2812_/B _3118_/C _3911_/D vdd gnd AOI21X1
X_3792_ _3792_/D _4100_/CLK _3792_/Q vdd gnd DFFPOSX1
X_3861_ _3861_/D _3885_/CLK _3861_/Q vdd gnd DFFPOSX1
XFILL_0__3233_ vdd gnd FILL
XFILL_0__2115_ vdd gnd FILL
XFILL_0__3164_ vdd gnd FILL
X_2674_ _2674_/A _3977_/D vdd gnd INVX1
XFILL_0__2046_ vdd gnd FILL
XFILL_0__2879_ vdd gnd FILL
X_3226_ _3627_/A _3627_/B _3708_/A _3227_/B vdd gnd MUX2X1
X_3157_ _3158_/A _3158_/B _4016_/Q _3160_/B vdd gnd OAI21X1
X_3088_ _3165_/C _3870_/B _3759_/D vdd gnd AND2X2
X_2108_ _2108_/A _2108_/B _2125_/B _2109_/C vdd gnd OAI21X1
X_2039_ _4071_/Q _3637_/B vdd gnd INVX1
XFILL_0__2733_ vdd gnd FILL
XFILL_0__2664_ vdd gnd FILL
X_2390_ _2390_/A _3698_/A _2390_/C _2593_/B vdd gnd AOI21X1
X_4060_ _4060_/D _3700_/A _4060_/Q vdd gnd DFFPOSX1
X_3011_ _3637_/A _3637_/B _3279_/S _3012_/A vdd gnd MUX2X1
X_3913_ _3913_/D _3979_/CLK _3913_/Q vdd gnd DFFPOSX1
XFILL_0__2595_ vdd gnd FILL
X_3844_ _3844_/D _3996_/CLK _3844_/Q vdd gnd DFFPOSX1
X_2726_ _2726_/A _2782_/B _3953_/D vdd gnd AND2X2
X_3775_ _3775_/D _3837_/CLK _3775_/Q vdd gnd DFFPOSX1
XFILL_0__3078_ vdd gnd FILL
X_2657_ _2668_/A _2690_/C _2813_/S _2659_/A vdd gnd OAI21X1
X_2588_ _2588_/A _4007_/D vdd gnd INVX1
XFILL_0__2029_ vdd gnd FILL
X_3209_ _4100_/Q _3211_/A vdd gnd INVX1
XBUFX2_insert164 _2694_/Y _2792_/B vdd gnd BUFX2
XBUFX2_insert175 _2817_/Y _2880_/A vdd gnd BUFX2
X_3560_ _3908_/Q _3563_/C vdd gnd INVX1
X_1890_ _3725_/Q _3727_/Q _1896_/C vdd gnd NOR2X1
X_2373_ _2373_/A _2535_/C _2373_/Y vdd gnd NOR2X1
X_2511_ _2511_/A _2511_/B _2511_/C _2525_/B vdd gnd OAI21X1
X_2442_ _2457_/C _2457_/A _3551_/B vdd gnd AND2X2
X_3491_ _3525_/A _3643_/B _3492_/C vdd gnd NAND2X1
X_4043_ _4043_/D _4045_/CLK _4043_/Q vdd gnd DFFPOSX1
XFILL_0__2578_ vdd gnd FILL
X_2709_ _2815_/A _2709_/B _2709_/C _2710_/A vdd gnd OAI21X1
X_3758_ _3758_/D _4053_/CLK _3870_/B vdd gnd DFFPOSX1
X_3689_ _3689_/A _3690_/C vdd gnd INVX1
X_3827_ _3827_/D _4016_/CLK _3827_/Q vdd gnd DFFPOSX1
XFILL129150x46950 vdd gnd FILL
XFILL_0__1880_ vdd gnd FILL
XFILL_0__3481_ vdd gnd FILL
XFILL_0__2363_ vdd gnd FILL
XFILL_0__2294_ vdd gnd FILL
XFILL_0__2432_ vdd gnd FILL
X_2991_ _3632_/A _3632_/B _3624_/A _2992_/A vdd gnd MUX2X1
X_1942_ _4095_/Q _3649_/B vdd gnd INVX1
X_1873_ _3725_/Q _1875_/A vdd gnd INVX1
X_3612_ _3796_/Q _3614_/C vdd gnd INVX1
X_3543_ _3552_/A _3657_/B _3544_/C vdd gnd NAND2X1
X_2356_ _3781_/Q _2356_/B _2356_/C _2357_/B vdd gnd NAND3X1
X_2425_ _3096_/A _3098_/B _3117_/A _2426_/B vdd gnd OAI21X1
X_3474_ _3474_/A _3474_/B _3549_/S _3956_/D vdd gnd MUX2X1
X_2287_ _2287_/A _2287_/B _2374_/B _2289_/C vdd gnd OAI21X1
X_4026_ _4026_/D _4058_/CLK _4026_/Q vdd gnd DFFPOSX1
XFILL129150x21750 vdd gnd FILL
X_2210_ _3771_/Q _2529_/B _2505_/A vdd gnd NOR2X1
X_3190_ _3862_/Y _3190_/B _3213_/B vdd gnd NAND2X1
XFILL_0__1863_ vdd gnd FILL
XFILL_0__3602_ vdd gnd FILL
X_2072_ _4065_/Q _3954_/Q _2136_/S _2073_/B vdd gnd MUX2X1
X_2141_ _3625_/B _2161_/B _2141_/C _2142_/A vdd gnd OAI21X1
XFILL_0__2277_ vdd gnd FILL
X_2974_ _2999_/A _3009_/B _3821_/Q _2978_/B vdd gnd OAI21X1
X_1925_ _3715_/Q _1925_/B _3084_/S _1926_/B vdd gnd MUX2X1
X_3526_ _3526_/A _3526_/B _3545_/S _3930_/D vdd gnd MUX2X1
X_2339_ _3791_/Q _2517_/A _2340_/A vdd gnd NOR2X1
X_2408_ _2408_/A _2408_/B _2433_/A vdd gnd NAND2X1
X_3388_ _3394_/B _3388_/B _3390_/B vdd gnd NAND2X1
X_3457_ _3488_/A _3966_/Q _3457_/C _3458_/B vdd gnd OAI21X1
X_4009_ _4009_/D _4009_/CLK _4009_/Q vdd gnd DFFPOSX1
XFILL_0__2131_ vdd gnd FILL
XFILL_0__3180_ vdd gnd FILL
X_2690_ _3969_/Q _2690_/B _2690_/C _2813_/S _2693_/B vdd gnd AOI22X1
X_3311_ _3311_/A _3311_/B _3311_/C _4062_/D vdd gnd OAI21X1
XFILL_0__2062_ vdd gnd FILL
XCLKBUF1_insert134 CLKBUF1_insert182/Y _3996_/CLK vdd gnd CLKBUF1
XCLKBUF1_insert156 CLKBUF1_insert180/Y _4084_/CLK vdd gnd CLKBUF1
X_2124_ _2124_/A _2124_/B _2125_/B _2125_/C vdd gnd OAI21X1
XCLKBUF1_insert123 CLKBUF1_insert183/Y _4041_/CLK vdd gnd CLKBUF1
XCLKBUF1_insert145 CLKBUF1_insert184/Y _3985_/CLK vdd gnd CLKBUF1
X_3173_ _3744_/Q _3641_/A vdd gnd INVX1
X_3242_ _4090_/Q _3242_/B _3314_/S _3244_/B vdd gnd MUX2X1
XFILL_0__3447_ vdd gnd FILL
X_2055_ _4067_/Q _3635_/B vdd gnd INVX1
XFILL_0__3516_ vdd gnd FILL
X_2957_ _4014_/Q _3015_/B _3834_/Q _2958_/B vdd gnd OAI21X1
X_2888_ _2896_/A _2888_/B _2888_/C _2889_/A vdd gnd OAI21X1
X_1908_ _2131_/A _1908_/Y vdd gnd INVX8
X_3509_ _3509_/A _3509_/B _3522_/S _3938_/D vdd gnd MUX2X1
XFILL_0__3301_ vdd gnd FILL
X_2742_ _2742_/A _2782_/B _3945_/D vdd gnd AND2X2
X_3791_ _3791_/D _4021_/CLK _3791_/Q vdd gnd DFFPOSX1
X_2811_ _2826_/S _2811_/B _2811_/C _2812_/B vdd gnd OAI21X1
X_3860_ _3860_/D _3893_/CLK _3860_/Q vdd gnd DFFPOSX1
XFILL_0__2947_ vdd gnd FILL
X_2673_ _2675_/A _2677_/C _2674_/A vdd gnd NAND2X1
X_3087_ _3707_/A _3087_/B _3761_/D vdd gnd NOR2X1
X_3156_ _3306_/A _3687_/A _3216_/B _3738_/D vdd gnd OAI21X1
X_3225_ _3780_/Q _3627_/A vdd gnd INVX1
X_2107_ _2123_/A _2107_/B _2108_/B vdd gnd NOR2X1
X_2038_ _2038_/A _2189_/C _4073_/D vdd gnd AND2X2
X_3989_ _3989_/D _3737_/D _3989_/Q vdd gnd DFFPOSX1
XFILL129150x126150 vdd gnd FILL
XFILL_0__2801_ vdd gnd FILL
X_3010_ _3760_/Q _3637_/A vdd gnd INVX1
XFILL_0__3215_ vdd gnd FILL
X_3843_ _3843_/D _3900_/CLK _3843_/Q vdd gnd DFFPOSX1
X_3912_ _3912_/D _3916_/CLK _3912_/Q vdd gnd DFFPOSX1
X_2725_ _2741_/A _2725_/B _2725_/C _2726_/A vdd gnd OAI21X1
X_2656_ _2658_/B _2690_/C vdd gnd INVX1
XFILL_0__3146_ vdd gnd FILL
X_3774_ _3910_/R vdd _3774_/D _3964_/CLK _3774_/Q vdd gnd DFFSR
X_2587_ _3988_/Q _2587_/B _2946_/C _2588_/A vdd gnd NAND3X1
X_3208_ _3208_/A _3293_/B _3208_/C _3208_/D _3714_/D vdd gnd AOI22X1
X_3139_ _3894_/Q _3650_/A vdd gnd INVX1
XBUFX2_insert110 _1908_/Y _2049_/A vdd gnd BUFX2
XBUFX2_insert165 _2694_/Y _2769_/A vdd gnd BUFX2
X_2510_ _3033_/B _3069_/B _2510_/C _2511_/C vdd gnd AOI21X1
XBUFX2_insert176 _2817_/Y _2896_/A vdd gnd BUFX2
XFILL_0__3000_ vdd gnd FILL
X_3490_ _3946_/Q _3493_/A vdd gnd INVX1
X_2372_ _4030_/Q _2535_/C vdd gnd INVX1
X_2441_ _2441_/A _2441_/B _3142_/A _2457_/C vdd gnd OAI21X1
XFILL_0__2715_ vdd gnd FILL
XFILL_0__2646_ vdd gnd FILL
X_4042_ _4042_/D _4093_/CLK _4042_/Q vdd gnd DFFPOSX1
XFILL_0__3695_ vdd gnd FILL
X_3826_ _3826_/D _4025_/CLK _3826_/Q vdd gnd DFFPOSX1
X_2708_ _3961_/Q _2815_/A _2709_/C vdd gnd NAND2X1
X_2639_ _2639_/A _2811_/B _2639_/C _3992_/D vdd gnd AOI21X1
X_3757_ _3757_/D _3885_/CLK _3870_/A vdd gnd DFFPOSX1
X_3688_ _3688_/A _3690_/B vdd gnd INVX1
XFILL_0__3129_ vdd gnd FILL
XFILL_0__2500_ vdd gnd FILL
X_2990_ _3770_/Q _3632_/A vdd gnd INVX1
X_1872_ _3707_/A _1872_/B _3727_/D vdd gnd NOR2X1
X_1941_ _2195_/C _1941_/B _4097_/D vdd gnd NOR2X1
X_3473_ _3548_/A _3958_/Q _3473_/C _3474_/B vdd gnd OAI21X1
X_3611_ _3613_/C _3611_/B _3611_/C _3611_/D _3800_/D vdd gnd OAI22X1
X_3542_ _3719_/Q _3657_/B vdd gnd INVX1
X_2355_ _2355_/A _2590_/A _2356_/C vdd gnd NAND2X1
X_2424_ _3755_/Q _3098_/B vdd gnd INVX1
X_2286_ _3414_/A _3732_/Q _2286_/C _2287_/B vdd gnd AOI21X1
XFILL_0__2629_ vdd gnd FILL
X_4025_ _4025_/D _4025_/CLK _4025_/Q vdd gnd DFFPOSX1
XFILL_0__3678_ vdd gnd FILL
X_3809_ _3809_/D _4076_/CLK _3809_/Q vdd gnd DFFPOSX1
XFILL_0__2980_ vdd gnd FILL
X_2140_ _2140_/A _2140_/B _2161_/B _2141_/C vdd gnd OAI21X1
XFILL_0__1931_ vdd gnd FILL
XFILL_0__2414_ vdd gnd FILL
XFILL_0__3463_ vdd gnd FILL
XFILL_0__3532_ vdd gnd FILL
X_2071_ _4063_/Q _3633_/B vdd gnd INVX1
XFILL_0__3394_ vdd gnd FILL
XFILL_0__2345_ vdd gnd FILL
X_2973_ _3014_/B _2973_/B _2973_/C _3824_/D vdd gnd AOI21X1
X_1924_ _1938_/B _1924_/B _1924_/C _1925_/B vdd gnd OAI21X1
X_3456_ _3548_/A _3634_/B _3457_/C vdd gnd NAND2X1
X_3525_ _3525_/A _3932_/Q _3525_/C _3526_/B vdd gnd OAI21X1
X_2338_ _2517_/A _3791_/Q _2340_/B vdd gnd AND2X2
X_2407_ _2408_/B _2408_/A _3615_/B vdd gnd OR2X2
X_2269_ _3738_/Q _3142_/A _3246_/A vdd gnd NOR2X1
X_3387_ _3387_/A _3991_/Q _3388_/B vdd gnd OR2X2
X_4008_ _4008_/D _4008_/CLK _4008_/Q vdd gnd DFFPOSX1
XFILL_0__2963_ vdd gnd FILL
X_3310_ _4062_/Q _3311_/A _3311_/C vdd gnd NAND2X1
XCLKBUF1_insert124 CLKBUF1_insert183/Y _3885_/CLK vdd gnd CLKBUF1
XCLKBUF1_insert135 CLKBUF1_insert181/Y _3917_/CLK vdd gnd CLKBUF1
XCLKBUF1_insert157 CLKBUF1_insert182/Y _3840_/CLK vdd gnd CLKBUF1
XFILL_0__2894_ vdd gnd FILL
XCLKBUF1_insert146 CLKBUF1_insert180/Y _3938_/CLK vdd gnd CLKBUF1
X_2123_ _2123_/A _2123_/B _2124_/B vdd gnd NOR2X1
XFILL_0__1914_ vdd gnd FILL
X_3241_ _3630_/A _3630_/B _3313_/S _3242_/B vdd gnd MUX2X1
X_3172_ _3853_/Y _3695_/C _3289_/C _3733_/D vdd gnd MUX2X1
XFILL_0__2328_ vdd gnd FILL
X_2054_ _2054_/A _2134_/B _4069_/D vdd gnd AND2X2
XFILL_0__3377_ vdd gnd FILL
XCLKBUF1_insert50 i_clk_fast _4021_/CLK vdd gnd CLKBUF1
X_2956_ _2956_/A _2956_/B _3003_/C _3836_/D vdd gnd AOI21X1
X_2887_ _3873_/Q _2896_/A _2888_/C vdd gnd NAND2X1
XFILL_0__2259_ vdd gnd FILL
X_1907_ _3729_/Q _1907_/B _3721_/Q _1912_/B vdd gnd OAI21X1
X_3439_ _3970_/Q _3439_/B _3441_/A vdd gnd NOR2X1
X_3508_ _3521_/A _3940_/Q _3508_/C _3509_/B vdd gnd OAI21X1
XFILL128250x46950 vdd gnd FILL
XFILL128850x93750 vdd gnd FILL
XFILL_0__3231_ vdd gnd FILL
X_2741_ _2741_/A _2741_/B _2741_/C _2742_/A vdd gnd OAI21X1
X_2810_ _2810_/A _2934_/B _2810_/C _2811_/C vdd gnd OAI21X1
X_2672_ _2943_/C _3292_/A _2677_/C vdd gnd NOR2X1
XFILL_0__3093_ vdd gnd FILL
XFILL_0__3162_ vdd gnd FILL
XFILL_0__2113_ vdd gnd FILL
XFILL_0__2044_ vdd gnd FILL
X_3790_ _3906_/R vdd _3790_/D _3954_/CLK _3790_/Q vdd gnd DFFSR
X_3224_ _3308_/B _3224_/B _3224_/C _4096_/D vdd gnd AOI21X1
.ends
