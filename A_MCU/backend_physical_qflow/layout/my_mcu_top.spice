* NGSPICE file created from my_mcu_top.ext - technology: scmos

* Black-box entry subcircuit for AOI21X1 abstract view
.subckt AOI21X1 A B C Y vdd gnd
.ends

* Black-box entry subcircuit for INVX1 abstract view
.subckt INVX1 A Y vdd gnd
.ends

* Black-box entry subcircuit for NOR2X1 abstract view
.subckt NOR2X1 A B Y vdd gnd
.ends

* Black-box entry subcircuit for NAND2X1 abstract view
.subckt NAND2X1 A B Y vdd gnd
.ends

* Black-box entry subcircuit for FILL abstract view
.subckt FILL vdd gnd
.ends

* Black-box entry subcircuit for DFFPOSX1 abstract view
.subckt DFFPOSX1 D CLK Q vdd gnd
.ends

* Black-box entry subcircuit for DFFSR abstract view
.subckt DFFSR R S D CLK Q vdd gnd
.ends

* Black-box entry subcircuit for OAI21X1 abstract view
.subckt OAI21X1 A B C Y vdd gnd
.ends

* Black-box entry subcircuit for BUFX2 abstract view
.subckt BUFX2 A Y vdd gnd
.ends

* Black-box entry subcircuit for MUX2X1 abstract view
.subckt MUX2X1 A B S Y vdd gnd
.ends

* Black-box entry subcircuit for OAI22X1 abstract view
.subckt OAI22X1 A B C D Y vdd gnd
.ends

* Black-box entry subcircuit for NAND3X1 abstract view
.subckt NAND3X1 A B C Y vdd gnd
.ends

* Black-box entry subcircuit for INVX2 abstract view
.subckt INVX2 A Y vdd gnd
.ends

* Black-box entry subcircuit for CLKBUF1 abstract view
.subckt CLKBUF1 A Y vdd gnd
.ends

* Black-box entry subcircuit for AND2X2 abstract view
.subckt AND2X2 A B Y vdd gnd
.ends

* Black-box entry subcircuit for OR2X2 abstract view
.subckt OR2X2 A B Y vdd gnd
.ends

* Black-box entry subcircuit for AOI22X1 abstract view
.subckt AOI22X1 A B C D Y vdd gnd
.ends

* Black-box entry subcircuit for INVX8 abstract view
.subckt INVX8 A Y vdd gnd
.ends

.subckt my_mcu_top gnd vdd i_clk_fast i_clk_sys_ext i_rst_n o_rf_sync o_rf_sck o_rf_mosi
+ i_rf_miso o_mem_sync o_mem_sck o_mem_mosi i_mem_miso
X_3086_ _3261_/C _3086_/B _3141_/C _3849_/D vdd gnd AOI21X1
X_3155_ _3487_/C _3157_/B vdd gnd INVX1
X_2106_ _4130_/Q _3742_/B vdd gnd INVX1
X_2037_ _2037_/A _2181_/B _2038_/A vdd gnd NOR2X1
X_2939_ _3927_/Q _2988_/A _2940_/C vdd gnd NAND2X1
XFILL_1__2084_ vdd gnd FILL
XFILL_0__3429_ vdd gnd FILL
X_3988_ _3988_/D _4036_/CLK _3988_/Q vdd gnd DFFPOSX1
XFILL_1__2986_ vdd gnd FILL
XFILL_1__3607_ vdd gnd FILL
XFILL_0__2731_ vdd gnd FILL
X_3842_ _4180_/R vdd _3842_/D _4166_/CLK _3842_/Q vdd gnd DFFSR
XFILL_0__3145_ vdd gnd FILL
X_3911_ _3911_/D _4084_/CLK _3911_/Q vdd gnd DFFPOSX1
X_2724_ _3841_/Q _4052_/Q _2725_/B vdd gnd NOR2X1
XFILL_0__3076_ vdd gnd FILL
X_3773_ _3926_/Y _3811_/Y _3774_/Y _3773_/Y vdd gnd OAI21X1
X_2655_ _2655_/A _2655_/B _4046_/D vdd gnd NOR2X1
X_2586_ _2586_/A _2592_/B _2586_/C _2587_/A vdd gnd OAI21X1
XFILL_0__2929_ vdd gnd FILL
XFILL_1__2771_ vdd gnd FILL
X_3207_ _3457_/B _3351_/B _3277_/A vdd gnd NOR2X1
X_4187_ _4187_/D _3214_/A _4187_/Q vdd gnd DFFPOSX1
X_3069_ _3069_/A _3069_/B _3070_/A vdd gnd NAND2X1
X_3138_ _3828_/Q _3734_/A vdd gnd INVX1
XFILL_1__2969_ vdd gnd FILL
XBUFX2_insert111 _2318_/Y _3364_/A vdd gnd BUFX2
XBUFX2_insert122 _1980_/Y _2152_/B vdd gnd BUFX2
XBUFX2_insert100 _1951_/Y _2158_/S vdd gnd BUFX2
XBUFX2_insert177 _3726_/Y _3750_/S vdd gnd BUFX2
XFILL_0__3901_ vdd gnd FILL
X_2440_ _3924_/Q _2440_/B _2440_/C _2445_/A vdd gnd OAI21X1
X_2371_ _2371_/A _3689_/B _2403_/C vdd gnd NAND2X1
X_4041_ _4041_/D _4049_/CLK _4041_/Q vdd gnd DFFPOSX1
X_4110_ _4110_/D _4114_/CLK _4110_/Q vdd gnd DFFPOSX1
XFILL_0__3763_ vdd gnd FILL
XFILL_0__2645_ vdd gnd FILL
X_3825_ _3825_/D _4147_/CLK _3825_/Q vdd gnd DFFPOSX1
X_3756_ _3756_/A _3756_/B _3760_/S _3939_/D vdd gnd MUX2X1
X_2638_ _2712_/B _3120_/C _3121_/A _4050_/D vdd gnd AOI21X1
XFILL_1__2823_ vdd gnd FILL
X_2569_ _2569_/A _2592_/B _3071_/C _4087_/D vdd gnd AOI21X1
XFILL_0__3059_ vdd gnd FILL
X_2707_ _2707_/A _2780_/B _2707_/C _2708_/A vdd gnd OAI21X1
X_3687_ _3688_/C _3688_/B _3687_/C _3688_/D _3858_/D vdd gnd OAI22X1
XFILL_1__3237_ vdd gnd FILL
XFILL_1__2119_ vdd gnd FILL
XFILL_0__2361_ vdd gnd FILL
XFILL_0__2430_ vdd gnd FILL
XFILL132750x100950 vdd gnd FILL
X_1940_ _4163_/Q _4165_/Q _3696_/B vdd gnd NOR2X1
X_3610_ _3988_/Q _3611_/A _3611_/C vdd gnd NOR2X1
X_2423_ _3462_/C _3464_/B vdd gnd INVX1
X_3541_ _3605_/A _4029_/Q _3541_/C _3543_/B vdd gnd OAI21X1
X_3472_ _3472_/A _3472_/B _3473_/B vdd gnd NOR2X1
X_4024_ _4024_/D _4050_/CLK _4024_/Q vdd gnd DFFPOSX1
X_2354_ _4039_/Q _2677_/B _2355_/C vdd gnd NAND2X1
XFILL_0__3746_ vdd gnd FILL
X_2285_ _4051_/Q _3525_/B _2285_/C _2387_/B vdd gnd OAI21X1
XFILL_0__2559_ vdd gnd FILL
XFILL_0__2628_ vdd gnd FILL
XBUFX2_insert0 _2781_/Y _2827_/B vdd gnd BUFX2
XFILL_1__3022_ vdd gnd FILL
X_3808_ _3851_/Q _3853_/Q _3808_/C _3809_/B vdd gnd NAND3X1
X_3739_ _3739_/A _3739_/B _3816_/S _4197_/D vdd gnd MUX2X1
XFILL_1__2806_ vdd gnd FILL
XFILL_1__2599_ vdd gnd FILL
XFILL_0__1930_ vdd gnd FILL
XFILL_0__3600_ vdd gnd FILL
X_2070_ _4138_/Q _3746_/B vdd gnd INVX1
XFILL_0__3393_ vdd gnd FILL
X_2972_ _2972_/A _2972_/B _2972_/C _2973_/A vdd gnd OAI21X1
XFILL_0__2344_ vdd gnd FILL
XFILL_0__3462_ vdd gnd FILL
XFILL_0__2275_ vdd gnd FILL
X_1923_ _4169_/Q _1926_/B _3773_/Y _1924_/C vdd gnd OAI21X1
X_2406_ _2895_/A _3022_/B vdd gnd INVX2
X_3386_ _4149_/Q _3386_/B _3391_/S _3388_/B vdd gnd MUX2X1
X_3524_ _3524_/A _3525_/B _3525_/C vdd gnd NAND2X1
X_3455_ _3455_/A _3472_/A _3475_/A _4057_/D vdd gnd MUX2X1
X_2337_ _4037_/Q _2530_/A vdd gnd INVX1
X_4007_ _4007_/D _4030_/CLK _4007_/Q vdd gnd DFFPOSX1
X_2268_ _3183_/A _3183_/B _2378_/B vdd gnd NOR2X1
X_2199_ _2199_/A _2650_/B _2200_/A vdd gnd NOR2X1
XFILL131850x64950 vdd gnd FILL
XFILL_0__2060_ vdd gnd FILL
XCLKBUF1_insert147 CLKBUF1_insert191/Y _4135_/CLK vdd gnd CLKBUF1
XFILL_0__2962_ vdd gnd FILL
XCLKBUF1_insert136 CLKBUF1_insert186/Y _4094_/CLK vdd gnd CLKBUF1
X_3240_ _3240_/A _3526_/S _3240_/C _4176_/D vdd gnd AOI21X1
XCLKBUF1_insert158 CLKBUF1_insert186/Y _4119_/CLK vdd gnd CLKBUF1
XCLKBUF1_insert169 CLKBUF1_insert191/Y _4040_/CLK vdd gnd CLKBUF1
X_3171_ _4178_/Q _4192_/Q _4193_/Q _3172_/B vdd gnd OAI21X1
X_2122_ _2122_/A _4126_/Q _2158_/S _2123_/B vdd gnd MUX2X1
X_2053_ _3748_/B _2170_/B _2056_/B vdd gnd NOR2X1
XCLKBUF1_insert62 i_clk_fast _2244_/A vdd gnd CLKBUF1
XFILL_0__3376_ vdd gnd FILL
X_2955_ _3918_/Q _2960_/A _2956_/C vdd gnd NAND2X1
X_2886_ _3948_/Q _2900_/A vdd gnd INVX1
XFILL_0__2258_ vdd gnd FILL
X_3507_ _3507_/A _3525_/B _3511_/A vdd gnd NOR2X1
XFILL_0__2189_ vdd gnd FILL
X_3369_ _3369_/A _3369_/B _3370_/B _3370_/D vdd gnd AOI21X1
X_3438_ _3440_/B _3438_/B _3453_/S _4073_/D vdd gnd MUX2X1
XFILL_1__2436_ vdd gnd FILL
XFILL_1__3554_ vdd gnd FILL
XFILL_0__3230_ vdd gnd FILL
XFILL_0__2112_ vdd gnd FILL
X_2740_ _2898_/C _2741_/D vdd gnd INVX1
XFILL_0__3092_ vdd gnd FILL
X_2671_ _4040_/Q _2764_/B vdd gnd INVX1
XFILL_0__2876_ vdd gnd FILL
XFILL_0__2945_ vdd gnd FILL
X_3223_ _3712_/B _3223_/B _3224_/B vdd gnd NOR2X1
X_3085_ _3085_/A _3310_/B _3261_/C vdd gnd NAND2X1
X_3154_ _3159_/A _3159_/B _3487_/C vdd gnd NOR2X1
X_2105_ _2186_/A _2105_/B _4130_/D vdd gnd NOR2X1
X_2036_ _2180_/A _4000_/Q _2037_/A vdd gnd NAND2X1
X_3987_ _3987_/D _3987_/CLK _3987_/Q vdd gnd DFFPOSX1
XFILL_0__3359_ vdd gnd FILL
X_2938_ _3925_/Q _3922_/Q _2986_/S _2940_/B vdd gnd MUX2X1
X_2869_ _2869_/A _2885_/B _3963_/D vdd gnd AND2X2
XFILL_1__3537_ vdd gnd FILL
XFILL_0__2592_ vdd gnd FILL
XFILL132450x111750 vdd gnd FILL
XFILL_0__2661_ vdd gnd FILL
X_3841_ _3841_/D _4054_/CLK _3841_/Q vdd gnd DFFPOSX1
X_2723_ _3829_/Q _3831_/Q _2725_/A vdd gnd NOR2X1
X_3910_ _3910_/D _4032_/CLK _3910_/Q vdd gnd DFFPOSX1
XFILL_0__3213_ vdd gnd FILL
X_3772_ _3773_/Y _3772_/Y vdd gnd INVX1
X_2585_ _2608_/A _2608_/B _4074_/Q _2586_/C vdd gnd OAI21X1
XFILL_0__2026_ vdd gnd FILL
X_2654_ _2654_/A _4046_/Q _2654_/S _2655_/B vdd gnd MUX2X1
XFILL_0__2859_ vdd gnd FILL
X_3137_ _3825_/Q _3323_/C _3141_/B vdd gnd NAND2X1
X_3206_ _3459_/B _3790_/A _3358_/C _4189_/D vdd gnd MUX2X1
X_4186_ _4201_/R vdd _4186_/D _4197_/CLK _4186_/Q vdd gnd DFFSR
X_3068_ _3859_/Q _3069_/A vdd gnd INVX1
XFILL_1__3184_ vdd gnd FILL
X_2019_ _2019_/A _2163_/B _2020_/A vdd gnd NOR2X1
XFILL_1__2066_ vdd gnd FILL
XBUFX2_insert112 _2318_/Y _3391_/S vdd gnd BUFX2
XBUFX2_insert123 _1980_/Y _2179_/B vdd gnd BUFX2
XBUFX2_insert101 _1951_/Y _2176_/S vdd gnd BUFX2
XBUFX2_insert178 _3726_/Y _3747_/S vdd gnd BUFX2
XFILL_0__2713_ vdd gnd FILL
X_4040_ _4040_/D _4040_/CLK _4040_/Q vdd gnd DFFPOSX1
X_2370_ _2370_/A _2370_/B _2371_/A vdd gnd NAND2X1
XFILL_0__3693_ vdd gnd FILL
XFILL_0__2575_ vdd gnd FILL
XFILL_0__3127_ vdd gnd FILL
X_3824_ _3947_/S vdd _3824_/D _4201_/CLK _3824_/Q vdd gnd DFFSR
X_2706_ _2706_/A _2780_/B vdd gnd INVX1
X_3755_ _3755_/A _3755_/B _3755_/S _3943_/D vdd gnd MUX2X1
X_3686_ _3858_/Q _3688_/C vdd gnd INVX1
X_2637_ _3110_/A _2637_/B _2637_/C _3120_/C vdd gnd NAND3X1
X_2499_ _4091_/Q _2562_/C vdd gnd INVX1
X_2568_ _2568_/A _2584_/A _4087_/Q _2569_/A vdd gnd OAI21X1
XFILL_1__2753_ vdd gnd FILL
XFILL_0__2009_ vdd gnd FILL
XFILL_1_BUFX2_insert109 vdd gnd FILL
X_4169_ _4169_/D _4183_/CLK _4169_/Q vdd gnd DFFPOSX1
XFILL_1__3167_ vdd gnd FILL
XFILL_1__2049_ vdd gnd FILL
XFILL_0__2291_ vdd gnd FILL
X_3540_ _3605_/A _3738_/B _3541_/C vdd gnd NAND2X1
X_2353_ _2353_/A _2353_/B _2677_/B vdd gnd NAND2X1
X_3471_ _3471_/A _3471_/B _3475_/A _4055_/D vdd gnd AOI21X1
X_2422_ _2422_/A _3169_/B _3170_/A _2434_/C vdd gnd NAND3X1
XFILL_0__3814_ vdd gnd FILL
XFILL_0__2627_ vdd gnd FILL
XBUFX2_insert1 _2781_/Y _2903_/A vdd gnd BUFX2
X_2284_ _3487_/B _3488_/A _2399_/A _2285_/C vdd gnd NAND3X1
X_4023_ _4023_/D _4034_/CLK _4023_/Q vdd gnd DFFPOSX1
XFILL_0__3676_ vdd gnd FILL
XFILL_0__2489_ vdd gnd FILL
X_3807_ _3807_/A _3807_/B _3808_/C vdd gnd NOR2X1
X_3738_ _3738_/A _3738_/B _3750_/S _4201_/D vdd gnd MUX2X1
X_1999_ _3755_/B _2179_/B _2002_/B vdd gnd NOR2X1
X_3669_ _3895_/Q _3672_/C vdd gnd INVX1
XFILL132450x21750 vdd gnd FILL
XFILL_0__3530_ vdd gnd FILL
X_2971_ _3910_/Q _2972_/A _2972_/C vdd gnd NAND2X1
XFILL_0__2412_ vdd gnd FILL
X_1922_ _3715_/B _3763_/Y _1926_/B vdd gnd NAND2X1
X_3523_ _4038_/Q _3626_/B _3527_/C vdd gnd NAND2X1
X_2336_ _2336_/A _2336_/B _2493_/C _2342_/C vdd gnd OAI21X1
X_2405_ _3944_/Q _2428_/A vdd gnd INVX1
X_3385_ _3385_/A _3385_/B _3385_/C _4125_/D vdd gnd OAI21X1
XFILL_0__1989_ vdd gnd FILL
X_3454_ _4053_/Q _3472_/A vdd gnd INVX1
XFILL_1__2383_ vdd gnd FILL
X_2267_ _4199_/Q _3818_/Q _3817_/Q _3183_/B vdd gnd NAND3X1
XFILL_0__3728_ vdd gnd FILL
X_2198_ _2649_/A _4043_/Q _2199_/A vdd gnd NAND2X1
X_4006_ _4006_/D _4036_/CLK _4006_/Q vdd gnd DFFPOSX1
XFILL_1__3004_ vdd gnd FILL
XFILL_1_CLKBUF1_insert127 vdd gnd FILL
XFILL_1_CLKBUF1_insert149 vdd gnd FILL
XFILL132150x68550 vdd gnd FILL
XFILL_0__2892_ vdd gnd FILL
XFILL_0__1912_ vdd gnd FILL
X_3170_ _3170_/A _3170_/B _3693_/B vdd gnd AND2X2
XCLKBUF1_insert159 CLKBUF1_insert191/Y _4200_/CLK vdd gnd CLKBUF1
XCLKBUF1_insert137 CLKBUF1_insert186/Y _4100_/CLK vdd gnd CLKBUF1
XCLKBUF1_insert148 CLKBUF1_insert186/Y _3961_/CLK vdd gnd CLKBUF1
XFILL132150x122550 vdd gnd FILL
X_2052_ _4142_/Q _3748_/B vdd gnd INVX1
X_2121_ _2157_/A _2121_/B _2121_/C _2122_/A vdd gnd OAI21X1
XFILL_0__3444_ vdd gnd FILL
XFILL_0__3513_ vdd gnd FILL
X_2885_ _2885_/A _2885_/B _3954_/D vdd gnd AND2X2
XFILL_0__2326_ vdd gnd FILL
X_2954_ _3916_/Q _3914_/Q _2986_/S _2956_/B vdd gnd MUX2X1
XFILL_0__2257_ vdd gnd FILL
XCLKBUF1_insert63 i_clk_fast _3214_/A vdd gnd CLKBUF1
X_3506_ _3507_/A _3506_/B _3626_/B _4045_/D vdd gnd MUX2X1
XFILL_1__1952_ vdd gnd FILL
X_2319_ _4015_/Q _3152_/A _3358_/C _2685_/S vdd gnd NAND3X1
X_3368_ _4179_/Q _4141_/Q _3368_/C _3370_/C vdd gnd OAI21X1
X_3299_ _3834_/Q _3731_/A vdd gnd INVX1
X_3437_ _4073_/Q _3440_/B vdd gnd INVX1
XFILL_1__2366_ vdd gnd FILL
XFILL_1__3484_ vdd gnd FILL
XFILL132150x43350 vdd gnd FILL
XFILL132750x90150 vdd gnd FILL
XFILL_0__3160_ vdd gnd FILL
X_2670_ _4015_/Q _2764_/A vdd gnd INVX1
XFILL_0__2042_ vdd gnd FILL
XFILL_0__2944_ vdd gnd FILL
X_3153_ _4199_/Q _3159_/A vdd gnd INVX1
X_2104_ _2104_/A _4130_/Q _2158_/S _2105_/B vdd gnd MUX2X1
X_3222_ _3222_/A _3227_/B vdd gnd INVX1
X_3084_ _3742_/A _3742_/B _3390_/S _3085_/A vdd gnd MUX2X1
XFILL_0__3427_ vdd gnd FILL
X_2035_ _3750_/B _2188_/B _2038_/B vdd gnd NOR2X1
XFILL_1__2220_ vdd gnd FILL
X_2868_ _2880_/A _2868_/B _2868_/C _2869_/A vdd gnd OAI21X1
XFILL_0__3358_ vdd gnd FILL
X_2937_ _2937_/A _3976_/R _3929_/D vdd gnd AND2X2
X_3986_ _3986_/D _4121_/D _3986_/Q vdd gnd DFFPOSX1
X_2799_ _3997_/Q _2903_/A _2800_/C vdd gnd NAND2X1
XFILL_1__2418_ vdd gnd FILL
X_2722_ _3825_/Q _3827_/Q _2726_/C vdd gnd NOR2X1
XFILL_0__3074_ vdd gnd FILL
X_3840_ _4180_/R vdd _3840_/D _4193_/CLK _3840_/Q vdd gnd DFFSR
XFILL_0__3143_ vdd gnd FILL
X_3771_ _3771_/A _3772_/Y _3771_/Y vdd gnd NOR2X1
X_2584_ _2584_/A _2584_/B _4076_/D vdd gnd NOR2X1
XFILL_0__2927_ vdd gnd FILL
X_2653_ _2653_/A _2653_/B _2653_/C _2654_/A vdd gnd OAI21X1
X_4185_ _4185_/D _3214_/A _4185_/Q vdd gnd DFFPOSX1
X_3136_ _3136_/A _3136_/B _3827_/D vdd gnd AND2X2
XFILL_1__3321_ vdd gnd FILL
X_3067_ _3861_/Q _3067_/B _3859_/Q _3070_/B vdd gnd OAI21X1
X_3205_ _3943_/Q _4155_/Q _3286_/A _3790_/A vdd gnd MUX2X1
X_2018_ _2171_/A _3996_/Q _2019_/A vdd gnd NAND2X1
XFILL_1__2203_ vdd gnd FILL
X_3969_ _3969_/D _3977_/CLK _3969_/Q vdd gnd DFFPOSX1
XFILL_1__2898_ vdd gnd FILL
XFILL_1__3519_ vdd gnd FILL
XBUFX2_insert113 _2318_/Y _3323_/C vdd gnd BUFX2
XBUFX2_insert179 _3726_/Y _3816_/S vdd gnd BUFX2
XBUFX2_insert124 _1980_/Y _2188_/B vdd gnd BUFX2
XBUFX2_insert102 _1951_/Y _2131_/S vdd gnd BUFX2
XFILL_0__3761_ vdd gnd FILL
XFILL_0__2643_ vdd gnd FILL
XFILL_0__2574_ vdd gnd FILL
X_3823_ _3823_/D _3806_/A _3823_/Q vdd gnd DFFPOSX1
X_2636_ _3038_/A _2637_/C vdd gnd INVX1
XFILL_0__3057_ vdd gnd FILL
X_2705_ _3022_/B _2705_/B _2769_/A _2706_/A vdd gnd OAI21X1
X_3754_ _3943_/Q _3755_/A vdd gnd INVX1
X_3685_ _3687_/C _3688_/B _3685_/C _3688_/D _3862_/D vdd gnd OAI22X1
X_2567_ _2573_/A _4081_/Q _2568_/A vdd gnd OR2X2
X_2498_ _2498_/A _2498_/B _2498_/C _2498_/Y vdd gnd AOI21X1
XFILL_1__2683_ vdd gnd FILL
X_3119_ _3121_/A _3119_/B _3835_/D vdd gnd NOR2X1
X_4168_ _4168_/D _4172_/CLK _4168_/Q vdd gnd DFFPOSX1
X_4099_ _4099_/D _4148_/CLK _4099_/Q vdd gnd DFFPOSX1
X_2352_ _3855_/Q _4042_/Q _2353_/B vdd gnd NOR2X1
X_2421_ _2421_/A _2421_/B _2421_/C _3169_/B vdd gnd OAI21X1
X_3470_ _3470_/A _3470_/B _3471_/B vdd gnd NAND2X1
XFILL_0__3744_ vdd gnd FILL
X_2283_ _2283_/A _2283_/B _2399_/A vdd gnd NAND2X1
X_4022_ _4022_/D _4050_/CLK _4022_/Q vdd gnd DFFPOSX1
XFILL_0__2557_ vdd gnd FILL
XBUFX2_insert2 _2781_/Y _2843_/B vdd gnd BUFX2
XFILL_0__3675_ vdd gnd FILL
X_3806_ _3806_/A _3806_/Y vdd gnd INVX1
X_2619_ _3136_/B _3048_/B _3121_/A vdd gnd NAND2X1
X_3737_ _3737_/A _3737_/B _3747_/S _3822_/D vdd gnd MUX2X1
X_3599_ _3599_/A _3599_/B _3599_/C _3994_/D vdd gnd AOI21X1
X_3668_ _3670_/C _3683_/B _3668_/C _3683_/D _3899_/D vdd gnd OAI22X1
X_1998_ _4155_/Q _3755_/B vdd gnd INVX1
XFILL_1__2735_ vdd gnd FILL
XFILL_1_BUFX2_insert83 vdd gnd FILL
XFILL_1_BUFX2_insert61 vdd gnd FILL
XFILL_1__3149_ vdd gnd FILL
XFILL_0__3391_ vdd gnd FILL
XFILL_0__3460_ vdd gnd FILL
XFILL_0__2342_ vdd gnd FILL
X_2970_ _3908_/Q _3906_/Q _2986_/S _2972_/B vdd gnd MUX2X1
XFILL_0__2273_ vdd gnd FILL
X_1921_ _1921_/A _1921_/B _3771_/A _4171_/D vdd gnd AOI21X1
X_3522_ _3525_/A _3522_/B _3522_/C _3522_/D _4041_/D vdd gnd OAI22X1
X_3453_ _3453_/A _3455_/A _3453_/S _4059_/D vdd gnd MUX2X1
X_2335_ _2494_/A _2602_/A _2563_/B _2606_/A _2336_/B vdd gnd OAI22X1
XFILL_1__2520_ vdd gnd FILL
X_3384_ _3384_/A _3385_/B _3385_/C vdd gnd NAND2X1
X_2404_ _3689_/A _3460_/B _2404_/C _3144_/A vdd gnd NAND3X1
X_2266_ _4200_/Q _3183_/A vdd gnd INVX2
X_4005_ _4005_/D _4147_/CLK _4005_/Q vdd gnd DFFPOSX1
XFILL_0__3658_ vdd gnd FILL
X_2197_ _3732_/B _2648_/B _2200_/B vdd gnd NOR2X1
XFILL_1__2718_ vdd gnd FILL
XFILL_0__2960_ vdd gnd FILL
XFILL_0__2891_ vdd gnd FILL
XCLKBUF1_insert127 CLKBUF1_insert189/Y _3908_/CLK vdd gnd CLKBUF1
XCLKBUF1_insert149 CLKBUF1_insert190/Y _4032_/CLK vdd gnd CLKBUF1
XCLKBUF1_insert138 CLKBUF1_insert188/Y _4182_/CLK vdd gnd CLKBUF1
X_2120_ _4096_/Q _3941_/Q _2120_/S _2121_/B vdd gnd MUX2X1
XFILL_0__3374_ vdd gnd FILL
XFILL_0__3512_ vdd gnd FILL
X_2051_ _2177_/A _2051_/B _4142_/D vdd gnd NOR2X1
X_2884_ _2900_/B _2884_/B _2884_/C _2885_/A vdd gnd OAI21X1
X_2953_ _2953_/A _4197_/R _3920_/D vdd gnd AND2X2
XFILL_0__2187_ vdd gnd FILL
XCLKBUF1_insert64 i_clk_fast _4148_/CLK vdd gnd CLKBUF1
X_3505_ _3625_/A _3505_/B _3505_/C _3506_/B vdd gnd OAI21X1
X_3436_ _3438_/B _3436_/B _3453_/S _4075_/D vdd gnd MUX2X1
X_2249_ _4076_/Q _4079_/Q _2250_/B vdd gnd NOR2X1
X_3367_ _4179_/Q _3802_/B _3373_/D _3368_/C vdd gnd OAI21X1
X_2318_ _3724_/B _2318_/B _3810_/B _2318_/Y vdd gnd NAND3X1
X_3298_ _3385_/B _3298_/B _3298_/C _4153_/D vdd gnd AOI21X1
XFILL_0__3090_ vdd gnd FILL
XFILL_0__2110_ vdd gnd FILL
XFILL132750x108150 vdd gnd FILL
XFILL_0__2874_ vdd gnd FILL
X_3083_ _4184_/Q _3742_/A vdd gnd INVX1
X_3152_ _3152_/A _3152_/B _3926_/A _3819_/D vdd gnd AOI21X1
X_2103_ _2157_/A _2103_/B _2103_/C _2104_/A vdd gnd OAI21X1
X_3221_ _3239_/A _3773_/Y _3770_/Y _3221_/D _4183_/D vdd gnd AOI22X1
X_3985_ _3985_/D _3985_/CLK _3985_/Q vdd gnd DFFPOSX1
XFILL_0__2308_ vdd gnd FILL
XFILL_1__2150_ vdd gnd FILL
X_2034_ _4146_/Q _3750_/B vdd gnd INVX1
X_2867_ _3963_/Q _2880_/A _2868_/C vdd gnd NAND2X1
X_2798_ _3995_/Q _3993_/Q _2895_/A _2800_/B vdd gnd MUX2X1
X_2936_ _2988_/A _2936_/B _2936_/C _2937_/A vdd gnd OAI21X1
XFILL_0__3288_ vdd gnd FILL
X_3419_ _4094_/Q _3422_/B vdd gnd INVX1
XFILL_1__1934_ vdd gnd FILL
XFILL_1__3466_ vdd gnd FILL
XFILL_1__2348_ vdd gnd FILL
XFILL_0__2590_ vdd gnd FILL
XFILL_0__3211_ vdd gnd FILL
X_2721_ _2721_/A _2721_/B _2726_/A vdd gnd AND2X2
X_3770_ _3771_/Y _3770_/Y vdd gnd INVX1
XFILL_0__2024_ vdd gnd FILL
XFILL_0__3142_ vdd gnd FILL
X_2652_ _4053_/Q _3823_/Q _2652_/S _2653_/B vdd gnd MUX2X1
X_2583_ _2758_/A _2583_/B _2584_/B vdd gnd NAND2X1
X_3204_ _3905_/Y _3795_/A _3382_/B _4190_/D vdd gnd MUX2X1
XFILL_0__2857_ vdd gnd FILL
X_3135_ _3135_/A _3369_/A _3321_/C _3136_/A vdd gnd OAI21X1
XFILL_0__2788_ vdd gnd FILL
X_3066_ _3152_/A _3066_/B _3071_/C _3861_/D vdd gnd AOI21X1
X_4184_ _4197_/R vdd _4184_/D _4184_/CLK _4184_/Q vdd gnd DFFSR
X_2017_ _3752_/B _2170_/B _2020_/B vdd gnd NOR2X1
X_2919_ _3938_/Q _3008_/A _2920_/C vdd gnd NAND2X1
X_3968_ _4201_/R vdd _3968_/D _4121_/D _3968_/Q vdd gnd DFFSR
XFILL_0__3409_ vdd gnd FILL
X_3899_ _3899_/D _4119_/CLK _3899_/Q vdd gnd DFFPOSX1
XFILL_1__3449_ vdd gnd FILL
XBUFX2_insert114 _2318_/Y _3382_/B vdd gnd BUFX2
XBUFX2_insert125 _1980_/Y _2648_/B vdd gnd BUFX2
XBUFX2_insert103 _1951_/Y _2185_/S vdd gnd BUFX2
XFILL_0__2711_ vdd gnd FILL
XFILL_0__3691_ vdd gnd FILL
XFILL_0__3125_ vdd gnd FILL
X_3822_ _4201_/R vdd _3822_/D _4182_/CLK _3822_/Q vdd gnd DFFSR
X_2635_ _3833_/Q _3035_/B _3038_/A vdd gnd NAND2X1
X_2704_ _2774_/B _2769_/A vdd gnd INVX1
X_3753_ _3753_/A _3753_/B _3760_/S _3947_/D vdd gnd MUX2X1
XFILL_0__2007_ vdd gnd FILL
X_3684_ _3862_/Q _3687_/C vdd gnd INVX1
X_2497_ _2497_/A _2497_/B _2498_/A vdd gnd NAND2X1
X_2566_ _2608_/B _2581_/B _2584_/A vdd gnd NOR2X1
XFILL_0__2909_ vdd gnd FILL
X_4167_ _4167_/D _4183_/CLK _4167_/Q vdd gnd DFFPOSX1
X_3118_ _3118_/A _3118_/B _3119_/B vdd gnd NAND2X1
X_3049_ _3870_/Q _3049_/B _3136_/B _3050_/C vdd gnd OAI21X1
XFILL_1__3303_ vdd gnd FILL
X_4098_ _4098_/D _4100_/CLK _4098_/Q vdd gnd DFFPOSX1
XFILL_1__3096_ vdd gnd FILL
X_2420_ _2420_/A _2420_/B _3170_/A vdd gnd NAND2X1
X_2351_ _3851_/Q _3853_/Q _2353_/A vdd gnd NOR2X1
XFILL_0__3812_ vdd gnd FILL
X_4021_ _4021_/D _4034_/CLK _4021_/Q vdd gnd DFFPOSX1
X_2282_ _3504_/B _4049_/Q _3503_/A _2283_/B vdd gnd NAND3X1
XBUFX2_insert3 _2781_/Y _2900_/B vdd gnd BUFX2
XFILL_0__2487_ vdd gnd FILL
XFILL_0__2625_ vdd gnd FILL
XFILL_0__3108_ vdd gnd FILL
X_3736_ _3736_/A _3736_/B _3816_/S _3824_/D vdd gnd MUX2X1
X_1997_ _2177_/A _1997_/B _4155_/D vdd gnd NOR2X1
X_3805_ _4121_/Q _3806_/Y _3805_/Y vdd gnd NOR2X1
X_2549_ _2549_/A _2549_/B _2550_/B vdd gnd NAND2X1
XFILL_0__3039_ vdd gnd FILL
X_2618_ _4054_/Q _3103_/B _3058_/B _3048_/B vdd gnd NAND3X1
XFILL_1__3783_ vdd gnd FILL
X_3598_ _3994_/Q _3599_/A _3599_/C vdd gnd NOR2X1
X_3667_ _3899_/Q _3670_/C vdd gnd INVX1
XFILL132150x28950 vdd gnd FILL
XFILL_1__2665_ vdd gnd FILL
XFILL132750x75750 vdd gnd FILL
XFILL_1__3079_ vdd gnd FILL
XFILL_0__2341_ vdd gnd FILL
XFILL_0__2410_ vdd gnd FILL
X_1920_ _3763_/Y _3715_/B _3772_/Y _1921_/A vdd gnd AOI21X1
X_3383_ _3383_/A _3383_/B _3384_/A vdd gnd NAND2X1
X_2403_ _2403_/A _2403_/B _2403_/C _2404_/C vdd gnd OAI21X1
X_3521_ _3526_/S _4109_/Q _3522_/B _3522_/D vdd gnd OAI21X1
X_3452_ _4057_/Q _3455_/A vdd gnd INVX1
X_2334_ _4019_/Q _2516_/B _2685_/S _2517_/A _2606_/A vdd gnd AOI22X1
XFILL_0__3726_ vdd gnd FILL
X_2265_ _2265_/A _4190_/Q _4196_/Q _3466_/C vdd gnd AOI21X1
X_4004_ _4004_/D _4027_/CLK _4004_/Q vdd gnd DFFPOSX1
XFILL_0__1987_ vdd gnd FILL
X_2196_ _4109_/Q _3732_/B vdd gnd INVX1
XFILL_0__2539_ vdd gnd FILL
XFILL_0__2608_ vdd gnd FILL
XFILL_0__3588_ vdd gnd FILL
XFILL132750x50550 vdd gnd FILL
X_3719_ _3719_/A _3719_/B _3719_/C _3719_/Y vdd gnd AOI21X1
XFILL_1__3766_ vdd gnd FILL
XCLKBUF1_insert139 CLKBUF1_insert187/Y _4172_/CLK vdd gnd CLKBUF1
XCLKBUF1_insert128 CLKBUF1_insert188/Y _4196_/CLK vdd gnd CLKBUF1
X_2050_ _2050_/A _4142_/Q _2176_/S _2051_/B vdd gnd MUX2X1
XFILL_0__2324_ vdd gnd FILL
X_2952_ _2960_/A _2952_/B _2952_/C _2953_/A vdd gnd OAI21X1
XFILL_0__3442_ vdd gnd FILL
X_2883_ _3954_/Q _2900_/B _2884_/C vdd gnd NAND2X1
XFILL_0__2255_ vdd gnd FILL
XCLKBUF1_insert65 i_clk_fast _4146_/CLK vdd gnd CLKBUF1
X_3366_ _4131_/Q _3378_/B _3382_/B _3373_/D vdd gnd NAND3X1
X_3504_ _3504_/A _3504_/B _3525_/B _3505_/B vdd gnd MUX2X1
X_3435_ _4075_/Q _3438_/B vdd gnd INVX1
XFILL_1__3620_ vdd gnd FILL
X_2248_ _4079_/Q _2482_/B _2252_/A vdd gnd NOR2X1
XFILL_1__2502_ vdd gnd FILL
X_2317_ _3228_/B _3812_/A _2318_/B vdd gnd NAND2X1
X_3297_ _4153_/Q _3385_/B _3298_/C vdd gnd NOR2X1
X_2179_ _3734_/B _2179_/B _2182_/B vdd gnd NOR2X1
XFILL_1__2295_ vdd gnd FILL
XFILL132450x97350 vdd gnd FILL
XFILL_0__2040_ vdd gnd FILL
XFILL_0__2942_ vdd gnd FILL
X_3220_ _4183_/Q _3239_/A vdd gnd INVX1
X_3082_ _3849_/Q _3344_/C _3086_/B vdd gnd NAND2X1
X_3151_ _3151_/A _4199_/Q _4031_/Q _3152_/B vdd gnd AOI21X1
X_2102_ _4090_/Q _3933_/Q _2120_/S _2103_/B vdd gnd MUX2X1
X_2033_ _2186_/A _2033_/B _4146_/D vdd gnd NOR2X1
X_2935_ _3929_/Q _2988_/A _2936_/C vdd gnd NAND2X1
XFILL_0__3356_ vdd gnd FILL
XFILL_0__3425_ vdd gnd FILL
X_3984_ _3984_/D _4182_/CLK _3984_/Q vdd gnd DFFPOSX1
X_2866_ _3960_/Q _3958_/Q _2878_/S _2868_/B vdd gnd MUX2X1
X_2797_ _2797_/A _3136_/B _3999_/D vdd gnd AND2X2
XFILL_1__2982_ vdd gnd FILL
XFILL_0__2169_ vdd gnd FILL
XFILL_0__2238_ vdd gnd FILL
XFILL_1_BUFX2_insert3 vdd gnd FILL
X_3349_ _3350_/B _3749_/A _3350_/C vdd gnd NAND2X1
XFILL_1__3603_ vdd gnd FILL
X_3418_ _3420_/B _3418_/B _3430_/S _4096_/D vdd gnd MUX2X1
XFILL132450x72150 vdd gnd FILL
XFILL_1__3396_ vdd gnd FILL
X_2582_ _3071_/C _2582_/B _4079_/D vdd gnd NOR2X1
X_2720_ _3849_/Q _4044_/Q _2721_/B vdd gnd NOR2X1
XFILL_0__3072_ vdd gnd FILL
X_2651_ _2651_/A _2651_/B _2653_/A _2653_/C vdd gnd OAI21X1
XFILL_0__2856_ vdd gnd FILL
XFILL_0__2925_ vdd gnd FILL
X_3203_ _4152_/Q _3235_/B _3203_/C _3795_/A vdd gnd OAI21X1
X_4183_ _4183_/D _4183_/CLK _4183_/Q vdd gnd DFFPOSX1
X_3134_ _3134_/A _3369_/A _3321_/C vdd gnd NAND2X1
X_3065_ _3065_/A _3069_/B _3066_/B vdd gnd NOR2X1
XFILL_1__3250_ vdd gnd FILL
X_2016_ _4150_/Q _3752_/B vdd gnd INVX1
X_3967_ _3967_/D _3987_/CLK _3967_/Q vdd gnd DFFPOSX1
X_3898_ _3898_/D _3908_/CLK _3898_/Q vdd gnd DFFPOSX1
XFILL_0__3339_ vdd gnd FILL
X_2918_ _3936_/Q _3934_/Q _3006_/S _2920_/B vdd gnd MUX2X1
XFILL_1__2132_ vdd gnd FILL
X_2849_ _2849_/A _2885_/B _3973_/D vdd gnd AND2X2
XFILL_1__1916_ vdd gnd FILL
XBUFX2_insert115 _2318_/Y _3344_/C vdd gnd BUFX2
XBUFX2_insert104 _1960_/Y _2227_/C vdd gnd BUFX2
XBUFX2_insert126 _1980_/Y _2170_/B vdd gnd BUFX2
XFILL_0__2572_ vdd gnd FILL
XFILL_0__2641_ vdd gnd FILL
X_3821_ _3821_/D _4199_/CLK _3917_/A vdd gnd DFFPOSX1
X_3752_ _3752_/A _3752_/B _3760_/S _3951_/D vdd gnd MUX2X1
X_2565_ _2571_/A _2565_/B _2565_/C _4089_/D vdd gnd AOI21X1
X_2634_ _4050_/Q _3103_/B _2634_/Y vdd gnd NOR2X1
XFILL_0__3055_ vdd gnd FILL
X_2703_ _2950_/S _4031_/Q _2774_/B vdd gnd NOR2X1
X_3683_ _3683_/A _3683_/B _3688_/A _3683_/D _3867_/D vdd gnd OAI22X1
XFILL_0__2006_ vdd gnd FILL
X_3117_ _3117_/A _3117_/B _3117_/C _3118_/A vdd gnd OAI21X1
XFILL_0__2839_ vdd gnd FILL
X_2496_ _2496_/A _2496_/B _2583_/B _2497_/A vdd gnd AOI21X1
X_4166_ _4166_/D _4166_/CLK _4166_/Q vdd gnd DFFPOSX1
X_3048_ _3048_/A _3048_/B _3050_/A vdd gnd NAND2X1
XFILL_1__3233_ vdd gnd FILL
X_4097_ _4097_/D _3214_/A _4097_/Q vdd gnd DFFPOSX1
XFILL_1__2115_ vdd gnd FILL
X_4020_ _4020_/D _4135_/CLK _4020_/Q vdd gnd DFFPOSX1
X_2350_ _4014_/Q _2764_/C vdd gnd INVX1
XFILL_0__3742_ vdd gnd FILL
XFILL_0__3673_ vdd gnd FILL
X_2281_ _3493_/B _3503_/A vdd gnd INVX1
XBUFX2_insert4 _2781_/Y _2796_/A vdd gnd BUFX2
XFILL_0__2555_ vdd gnd FILL
XFILL_0__2486_ vdd gnd FILL
XFILL_0__3107_ vdd gnd FILL
X_3735_ _3735_/A _3735_/B _3816_/S _3826_/D vdd gnd MUX2X1
X_1996_ _1996_/A _4155_/Q _2131_/S _1997_/B vdd gnd MUX2X1
X_3804_ _4202_/Q _3804_/Y vdd gnd INVX1
X_2548_ _4060_/Q _2548_/B _2548_/C _2549_/B vdd gnd NAND3X1
X_2617_ _4035_/Q _3073_/S _3058_/B vdd gnd NOR2X1
X_3597_ _3597_/A _3996_/Q _3597_/C _3599_/B vdd gnd OAI21X1
X_3666_ _3668_/C _3688_/B _3666_/C _3688_/D _3903_/D vdd gnd OAI22X1
X_2479_ _2479_/A _2479_/B _2479_/C _2497_/B vdd gnd OAI21X1
X_4149_ _4149_/D _4173_/CLK _4149_/Q vdd gnd DFFPOSX1
XFILL_1_BUFX2_insert30 vdd gnd FILL
XFILL_1_BUFX2_insert52 vdd gnd FILL
XFILL_1_BUFX2_insert74 vdd gnd FILL
XFILL_1_BUFX2_insert96 vdd gnd FILL
XFILL_0__2271_ vdd gnd FILL
X_3520_ _3525_/B _3520_/B _3520_/C _3522_/C vdd gnd AOI21X1
X_2333_ _2546_/B _3336_/A _2517_/A vdd gnd NOR2X1
X_3382_ _3382_/A _3382_/B _3383_/A vdd gnd NAND2X1
X_2402_ _4190_/Q _2402_/B _2433_/C _4061_/Q _2403_/B vdd gnd AOI22X1
X_3451_ _3704_/B _3709_/B _3469_/B _4061_/D vdd gnd MUX2X1
X_4003_ _4003_/D _4003_/CLK _4003_/Q vdd gnd DFFPOSX1
X_2264_ _2264_/A _2346_/A _2347_/C _2265_/A vdd gnd NAND3X1
XFILL_0__3656_ vdd gnd FILL
X_2195_ _2655_/A _2195_/B _4109_/D vdd gnd NOR2X1
XFILL_0__3587_ vdd gnd FILL
XFILL_0__2469_ vdd gnd FILL
X_3649_ _3937_/Q _3652_/C vdd gnd INVX1
X_3718_ _3718_/A _3718_/B _4185_/Q _3719_/C vdd gnd OAI21X1
X_1979_ _4159_/Q _3758_/B vdd gnd INVX1
XFILL_1__2647_ vdd gnd FILL
XCLKBUF1_insert129 CLKBUF1_insert189/Y _3987_/CLK vdd gnd CLKBUF1
XFILL_0__3510_ vdd gnd FILL
XFILL_0__2323_ vdd gnd FILL
XFILL132750x111750 vdd gnd FILL
XFILL_0__3372_ vdd gnd FILL
X_2951_ _3920_/Q _2960_/A _2952_/C vdd gnd NAND2X1
X_2882_ _3952_/Q _3950_/Q _2895_/A _2884_/B vdd gnd MUX2X1
XCLKBUF1_insert66 i_clk_fast _4089_/CLK vdd gnd CLKBUF1
X_3503_ _3503_/A _3503_/B _3504_/A vdd gnd NOR2X1
XFILL_0__2185_ vdd gnd FILL
X_3365_ _4129_/Q _3370_/A vdd gnd INVX1
X_3296_ _4156_/Q _3309_/B _3296_/C _3298_/B vdd gnd OAI21X1
X_2316_ _3390_/S _3812_/A vdd gnd INVX1
XFILL_1__3550_ vdd gnd FILL
X_3434_ _3436_/B _3434_/B _3453_/S _4077_/D vdd gnd MUX2X1
XFILL_0__1969_ vdd gnd FILL
X_2247_ _2579_/A _2482_/B vdd gnd INVX1
XFILL_1__2432_ vdd gnd FILL
X_2178_ _4113_/Q _3734_/B vdd gnd INVX1
XFILL_0__3708_ vdd gnd FILL
XFILL_1__3748_ vdd gnd FILL
XFILL_0__2872_ vdd gnd FILL
X_3150_ _3901_/A _3921_/A _3820_/D vdd gnd AND2X2
X_3081_ _3081_/A _3081_/B _3081_/C _3851_/D vdd gnd AOI21X1
XFILL_0__3424_ vdd gnd FILL
X_2101_ _2101_/A _2101_/B _2175_/A _2103_/C vdd gnd OAI21X1
X_2032_ _2032_/A _4146_/Q _2185_/S _2033_/B vdd gnd MUX2X1
X_2865_ _2865_/A _2885_/B _3965_/D vdd gnd AND2X2
X_3983_ _3983_/D _3985_/CLK _3983_/Q vdd gnd DFFPOSX1
XFILL_0__2306_ vdd gnd FILL
X_2934_ _3927_/Q _3925_/Q _2986_/S _2936_/B vdd gnd MUX2X1
XFILL_0__3286_ vdd gnd FILL
X_2796_ _2796_/A _2796_/B _2796_/C _2797_/A vdd gnd OAI21X1
XFILL_0__2099_ vdd gnd FILL
X_3348_ _3964_/Q _3749_/A vdd gnd INVX1
X_3279_ _3286_/A _3728_/A _3280_/C vdd gnd NAND2X1
X_3417_ _4096_/Q _3420_/B vdd gnd INVX1
XFILL_1__2277_ vdd gnd FILL
XFILL_0__3140_ vdd gnd FILL
X_2581_ _2608_/B _2581_/B _2581_/C _2582_/B vdd gnd OAI21X1
XFILL_0__2022_ vdd gnd FILL
X_2650_ _2650_/A _2650_/B _2651_/A vdd gnd NOR2X1
XFILL_0__2786_ vdd gnd FILL
X_3133_ _3735_/A _3735_/B _3390_/S _3134_/A vdd gnd MUX2X1
X_4182_ _4201_/R vdd _4182_/D _4182_/CLK _4182_/Q vdd gnd DFFSR
X_3202_ _3235_/B _3753_/A _3203_/C vdd gnd NAND2X1
X_3064_ _3861_/Q _3067_/B _3069_/B vdd gnd NOR2X1
XFILL_1__3180_ vdd gnd FILL
XFILL_0__3407_ vdd gnd FILL
X_2015_ _2177_/A _2015_/B _4150_/D vdd gnd NOR2X1
X_2848_ _2864_/A _2848_/B _2848_/C _2849_/A vdd gnd OAI21X1
X_2917_ _2917_/A _3976_/R _3940_/D vdd gnd AND2X2
X_3897_ _3897_/A _3901_/Y _3897_/Y vdd gnd OR2X2
X_3966_ _3966_/D _4071_/CLK _3966_/Q vdd gnd DFFPOSX1
XFILL_1__2062_ vdd gnd FILL
XFILL_1__2964_ vdd gnd FILL
X_2779_ _3947_/S _2779_/B _2780_/A vdd gnd NAND2X1
XBUFX2_insert116 _2318_/Y _3358_/C vdd gnd BUFX2
XFILL_1__3378_ vdd gnd FILL
XBUFX2_insert105 _1960_/Y _2182_/C vdd gnd BUFX2
XFILL131850x50550 vdd gnd FILL
XFILL_0__2640_ vdd gnd FILL
XFILL_0__3054_ vdd gnd FILL
X_3820_ _3820_/D _4199_/CLK _3921_/B vdd gnd DFFPOSX1
X_2702_ _2707_/A _2950_/S _2705_/B _2707_/C vdd gnd NAND3X1
XFILL_0__3123_ vdd gnd FILL
X_3751_ _3751_/A _3751_/B _3755_/S _3955_/D vdd gnd MUX2X1
X_3682_ _3931_/Q _3688_/A vdd gnd INVX1
X_2564_ _4089_/Q _2565_/B _2758_/A _2565_/C vdd gnd OAI21X1
X_2633_ _3117_/C _3103_/C _2637_/B vdd gnd NOR2X1
X_2495_ _2495_/A _2495_/B _2496_/A vdd gnd NOR2X1
X_3116_ _3120_/B _3118_/B vdd gnd INVX1
XFILL_0__2907_ vdd gnd FILL
XFILL_0__2769_ vdd gnd FILL
X_4165_ _4165_/D _4183_/CLK _4165_/Q vdd gnd DFFPOSX1
X_4096_ _4096_/D _4100_/CLK _4096_/Q vdd gnd DFFPOSX1
X_3047_ _3135_/A _3841_/Q _3047_/C _3048_/A vdd gnd AOI21X1
X_3949_ _3949_/D _4100_/CLK _3949_/Q vdd gnd DFFPOSX1
XFILL_1__2947_ vdd gnd FILL
XFILL_0__3810_ vdd gnd FILL
XFILL132450x122550 vdd gnd FILL
XFILL_0__2623_ vdd gnd FILL
XFILL_0__3741_ vdd gnd FILL
X_2280_ _4047_/Q _3504_/B vdd gnd INVX1
XBUFX2_insert5 _2781_/Y _2864_/A vdd gnd BUFX2
X_3803_ _4048_/Q _4097_/Q _3803_/Y vdd gnd NOR2X1
XFILL_0__3037_ vdd gnd FILL
X_2616_ _3072_/A _3072_/B _3073_/S vdd gnd NAND2X1
X_3734_ _3734_/A _3734_/B _3755_/S _3828_/D vdd gnd MUX2X1
X_3665_ _3903_/Q _3668_/C vdd gnd INVX1
X_1995_ _2182_/C _1995_/B _1995_/C _1996_/A vdd gnd OAI21X1
X_2478_ _2579_/A _2478_/B _2478_/C _2479_/C vdd gnd AOI21X1
XFILL_1__2801_ vdd gnd FILL
X_2547_ _2547_/A _2685_/S _2548_/C vdd gnd NAND2X1
XFILL132750x10950 vdd gnd FILL
X_3596_ _3597_/A _3752_/B _3597_/C vdd gnd NAND2X1
XFILL_1__2594_ vdd gnd FILL
X_4079_ _4079_/D _2244_/A _4079_/Q vdd gnd DFFPOSX1
X_4148_ _4148_/D _4148_/CLK _4148_/Q vdd gnd DFFPOSX1
XFILL_1__3215_ vdd gnd FILL
XFILL_1_CLKBUF1_insert65 vdd gnd FILL
X_2332_ _2579_/B _2563_/B vdd gnd INVX1
X_3381_ _3381_/A _3381_/B _3381_/C _3381_/D _3382_/A vdd gnd OAI22X1
XFILL_0__3724_ vdd gnd FILL
X_2401_ _2401_/A _2401_/B _2433_/C vdd gnd NAND2X1
XFILL_0__1985_ vdd gnd FILL
X_3450_ _3475_/A _3450_/B _3479_/B _3469_/B vdd gnd MUX2X1
XFILL_0__2537_ vdd gnd FILL
XFILL_0__2606_ vdd gnd FILL
X_2263_ _3196_/A _3708_/A _2347_/C vdd gnd NAND2X1
X_4002_ _4002_/D _4036_/CLK _4002_/Q vdd gnd DFFPOSX1
X_2194_ _2194_/A _4109_/Q _2654_/S _2195_/B vdd gnd MUX2X1
XFILL_1__3000_ vdd gnd FILL
XFILL_0__2399_ vdd gnd FILL
X_3648_ _3650_/C _3672_/B _3648_/C _3672_/D _3941_/D vdd gnd OAI22X1
X_3579_ _3599_/A _3579_/B _3579_/C _4004_/D vdd gnd AOI21X1
X_3717_ _3717_/A _3717_/B _3718_/B vdd gnd NAND2X1
X_1978_ _3771_/A _1978_/B _4159_/D vdd gnd NOR2X1
XFILL_1__3695_ vdd gnd FILL
XFILL132450x57750 vdd gnd FILL
XFILL_1__2577_ vdd gnd FILL
XFILL_0__3371_ vdd gnd FILL
XFILL_0__3440_ vdd gnd FILL
X_2881_ _2881_/A _2885_/B _3956_/D vdd gnd AND2X2
XFILL_0__2253_ vdd gnd FILL
XCLKBUF1_insert67 i_clk_fast _4101_/CLK vdd gnd CLKBUF1
X_2950_ _3918_/Q _3916_/Q _2950_/S _2952_/B vdd gnd MUX2X1
X_3502_ _3507_/A _3509_/A _3503_/B vdd gnd NOR2X1
X_3433_ _4077_/Q _3436_/B vdd gnd INVX1
X_2246_ _4081_/Q _4083_/Q _2579_/A vdd gnd NOR2X1
X_3364_ _3364_/A _3364_/B _3364_/C _4131_/D vdd gnd OAI21X1
X_3295_ _3295_/A _3309_/B _3296_/C vdd gnd NAND2X1
X_2315_ _4181_/Q _3228_/B vdd gnd INVX1
XFILL_0__3638_ vdd gnd FILL
XFILL_0__3569_ vdd gnd FILL
X_2177_ _2177_/A _2177_/B _4113_/D vdd gnd NOR2X1
XFILL_1__3678_ vdd gnd FILL
XFILL_0__2940_ vdd gnd FILL
X_3080_ _3081_/A _3081_/B _3080_/C _3081_/C vdd gnd OAI21X1
X_2100_ _2100_/A _2163_/B _2101_/A vdd gnd NOR2X1
XFILL_0__3354_ vdd gnd FILL
X_2031_ _2157_/A _2031_/B _2031_/C _2032_/A vdd gnd OAI21X1
X_3982_ _3982_/D _4036_/CLK _3982_/Q vdd gnd DFFPOSX1
X_2864_ _2864_/A _2864_/B _2864_/C _2865_/A vdd gnd OAI21X1
X_2795_ _3999_/Q _2796_/A _2796_/C vdd gnd NAND2X1
X_2933_ _2933_/A _3976_/R _3932_/D vdd gnd AND2X2
XFILL_0__2167_ vdd gnd FILL
XFILL_0__2236_ vdd gnd FILL
X_3416_ _3418_/B _3416_/B _3446_/S _4098_/D vdd gnd MUX2X1
X_3347_ _3347_/A _3393_/A _3353_/C vdd gnd NAND2X1
X_3278_ _3840_/Q _3728_/A vdd gnd INVX1
XFILL_1__3532_ vdd gnd FILL
X_2229_ _2653_/A _2229_/B _2229_/C _2230_/A vdd gnd OAI21X1
XFILL_1__2414_ vdd gnd FILL
XFILL132150x79350 vdd gnd FILL
XFILL_0__3070_ vdd gnd FILL
X_2580_ _2580_/A _2580_/B _4081_/D vdd gnd NOR2X1
XFILL_0__2923_ vdd gnd FILL
XFILL_0__2854_ vdd gnd FILL
X_3063_ _3063_/A _3065_/A vdd gnd INVX1
X_3132_ _3826_/Q _3735_/A vdd gnd INVX1
X_3201_ _3947_/Q _3753_/A vdd gnd INVX1
X_4181_ _4181_/D _3214_/A _4181_/Q vdd gnd DFFPOSX1
X_3965_ _3965_/D _3987_/CLK _3965_/Q vdd gnd DFFPOSX1
XFILL_0__3337_ vdd gnd FILL
X_2014_ _2014_/A _4150_/Q _2176_/S _2015_/B vdd gnd MUX2X1
X_2847_ _3973_/Q _2864_/A _2848_/C vdd gnd NAND2X1
X_3896_ _3896_/D _3997_/CLK _3896_/Q vdd gnd DFFPOSX1
X_2916_ _2928_/A _2916_/B _2916_/C _2917_/A vdd gnd OAI21X1
XFILL_0__3268_ vdd gnd FILL
X_2778_ _3022_/B _2778_/B _2778_/C _2779_/B vdd gnd OAI21X1
XFILL_1__2894_ vdd gnd FILL
XFILL132150x54150 vdd gnd FILL
XFILL_1__3515_ vdd gnd FILL
XBUFX2_insert117 _1966_/Y _2228_/S vdd gnd BUFX2
XBUFX2_insert106 _1960_/Y _2645_/A vdd gnd BUFX2
XFILL_0__2570_ vdd gnd FILL
X_2701_ _2701_/A _4031_/D vdd gnd INVX1
X_2632_ _3841_/Q _3103_/C vdd gnd INVX1
X_3750_ _3750_/A _3750_/B _3750_/S _3959_/D vdd gnd MUX2X1
XFILL_0__2004_ vdd gnd FILL
X_3681_ _3681_/A _3688_/B _3681_/C _3688_/D _3871_/D vdd gnd OAI22X1
X_2563_ _2573_/A _2563_/B _2565_/B vdd gnd NOR2X1
X_2494_ _2494_/A _2592_/A _2494_/C _2495_/A vdd gnd OAI21X1
X_3115_ _3117_/C _3115_/B _3120_/B vdd gnd NOR2X1
XFILL_0__2837_ vdd gnd FILL
X_3046_ _3841_/Q _3845_/Q _3047_/C vdd gnd NOR2X1
X_4095_ _4095_/D _2244_/A _4095_/Q vdd gnd DFFPOSX1
X_4164_ _4164_/D _4191_/CLK _4164_/Q vdd gnd DFFPOSX1
XFILL_0__2768_ vdd gnd FILL
X_3948_ _3948_/D _3987_/CLK _3948_/Q vdd gnd DFFPOSX1
XFILL_1__3162_ vdd gnd FILL
XFILL_1__2044_ vdd gnd FILL
X_3879_ _3879_/D _4106_/CLK _3879_/Q vdd gnd DFFPOSX1
XBUFX2_insert6 _2781_/Y _2880_/A vdd gnd BUFX2
XFILL_0__2553_ vdd gnd FILL
XFILL_0__3671_ vdd gnd FILL
XFILL_0__3105_ vdd gnd FILL
XFILL_0__2484_ vdd gnd FILL
X_3802_ _3802_/A _3802_/B _3802_/C _3802_/D _3877_/D vdd gnd OAI22X1
X_1994_ _4065_/Q _3883_/Q _3221_/D _1995_/B vdd gnd MUX2X1
X_2615_ _2615_/A _2615_/B _3072_/B vdd gnd AND2X2
X_3733_ _3733_/A _3733_/B _3750_/S _3830_/D vdd gnd MUX2X1
X_3595_ _3595_/A _3595_/B _3595_/C _3996_/D vdd gnd AOI21X1
X_3664_ _3666_/C _3683_/B _3664_/C _3688_/D _3907_/D vdd gnd OAI22X1
XFILL_1__2731_ vdd gnd FILL
X_2477_ _2563_/B _2586_/A _2493_/C _2478_/C vdd gnd OAI21X1
X_2546_ _3868_/Q _2546_/B _2548_/B vdd gnd NAND2X1
XFILL_1_BUFX2_insert21 vdd gnd FILL
X_4147_ _4147_/D _4147_/CLK _4147_/Q vdd gnd DFFPOSX1
XFILL_1_BUFX2_insert43 vdd gnd FILL
XFILL_0__3869_ vdd gnd FILL
X_3029_ _4050_/Q _3103_/B _3882_/Q _3031_/B vdd gnd OAI21X1
XFILL_1_BUFX2_insert87 vdd gnd FILL
X_4078_ _4078_/D _4183_/CLK _4078_/Q vdd gnd DFFPOSX1
XFILL_1__3145_ vdd gnd FILL
XFILL_1__2929_ vdd gnd FILL
XBUFX2_insert90 _4032_/Q _2994_/S vdd gnd BUFX2
X_2400_ _4178_/Q _3488_/C _2400_/C _2401_/B vdd gnd OAI21X1
X_2331_ _2331_/A _2468_/C _2579_/B vdd gnd NOR2X1
X_4001_ _4001_/D _4003_/CLK _4001_/Q vdd gnd DFFPOSX1
X_3380_ _4160_/Q _3380_/B _3381_/B _3381_/C vdd gnd OAI21X1
X_2262_ _4193_/Q _3708_/A vdd gnd INVX2
XFILL_0__1984_ vdd gnd FILL
XFILL_0__2605_ vdd gnd FILL
XFILL_0__3654_ vdd gnd FILL
XFILL_0__3585_ vdd gnd FILL
X_2193_ _2227_/C _2193_/B _2193_/C _2194_/A vdd gnd OAI21X1
XFILL_0__2467_ vdd gnd FILL
XFILL_0__2398_ vdd gnd FILL
X_3716_ _3717_/B _3717_/A _3716_/C _4183_/Q _3719_/B vdd gnd AOI22X1
X_1977_ _1977_/A _4159_/Q _2176_/S _1978_/B vdd gnd MUX2X1
X_2529_ _2529_/A _2529_/B _2529_/C _2541_/A vdd gnd NAND3X1
XFILL_0__3019_ vdd gnd FILL
X_3647_ _3941_/Q _3650_/C vdd gnd INVX1
X_3578_ _4004_/Q _3599_/A _3579_/C vdd gnd NOR2X1
XFILL_0__2321_ vdd gnd FILL
X_2880_ _2880_/A _2880_/B _2880_/C _2881_/A vdd gnd OAI21X1
XFILL_0__2183_ vdd gnd FILL
XCLKBUF1_insert68 i_clk_fast _4157_/CLK vdd gnd CLKBUF1
X_3363_ _4046_/Q _3363_/B _3363_/C _3364_/B vdd gnd OAI21X1
X_3501_ _3501_/A _3509_/A vdd gnd INVX1
X_3432_ _3434_/B _3432_/B _3453_/S _4080_/D vdd gnd MUX2X1
X_2245_ _4076_/Q _2562_/A vdd gnd INVX1
X_2314_ _2314_/A _2314_/B _2685_/B _3810_/B vdd gnd OAI21X1
X_3294_ _4105_/Q _3333_/A _3294_/C _3295_/A vdd gnd OAI21X1
X_2176_ _2176_/A _4113_/Q _2176_/S _2177_/B vdd gnd MUX2X1
XFILL_0__1967_ vdd gnd FILL
XFILL_0__3706_ vdd gnd FILL
XFILL_1__2361_ vdd gnd FILL
XFILL_0__3499_ vdd gnd FILL
XFILL_1__2559_ vdd gnd FILL
XFILL_0__2870_ vdd gnd FILL
X_2030_ _4073_/Q _3899_/Q _2228_/S _2031_/B vdd gnd MUX2X1
X_3981_ _3981_/D _3985_/CLK _3981_/Q vdd gnd DFFPOSX1
XFILL_0__2304_ vdd gnd FILL
X_2932_ _2988_/A _2932_/B _2932_/C _2933_/A vdd gnd OAI21X1
XFILL_0__3284_ vdd gnd FILL
XFILL_0__3422_ vdd gnd FILL
X_2863_ _3965_/Q _2900_/B _2864_/C vdd gnd NAND2X1
X_2794_ _3997_/Q _3995_/Q _3019_/A _2796_/B vdd gnd MUX2X1
XFILL_0__2097_ vdd gnd FILL
XFILL_0__2235_ vdd gnd FILL
X_3346_ _3346_/A _4137_/D vdd gnd INVX1
XFILL_1__1930_ vdd gnd FILL
X_3415_ _4098_/Q _3418_/B vdd gnd INVX1
X_3277_ _3277_/A _3277_/B _3373_/B _3385_/B vdd gnd AOI21X1
XFILL_1__3462_ vdd gnd FILL
X_2159_ _2186_/A _2159_/B _4118_/D vdd gnd NOR2X1
X_2228_ _4059_/Q _3858_/Q _2228_/S _2229_/B vdd gnd MUX2X1
XFILL_1__2344_ vdd gnd FILL
XFILL_0__2020_ vdd gnd FILL
XFILL131850x122550 vdd gnd FILL
XFILL_0__2922_ vdd gnd FILL
X_3200_ _3200_/A _3792_/A _3364_/A _4191_/D vdd gnd MUX2X1
X_4180_ _4180_/R vdd _4180_/D _4193_/CLK _4180_/Q vdd gnd DFFSR
XFILL_0__2784_ vdd gnd FILL
X_3131_ _3324_/C _3131_/B _3141_/C _3829_/D vdd gnd AOI21X1
X_3062_ _3863_/Q _3062_/B _3861_/Q _3063_/A vdd gnd OAI21X1
X_2013_ _2175_/A _2013_/B _2013_/C _2014_/A vdd gnd OAI21X1
X_2915_ _3940_/Q _2928_/A _2916_/C vdd gnd NAND2X1
XFILL_0__3336_ vdd gnd FILL
X_3964_ _4201_/R vdd _3964_/D _4201_/CLK _3964_/Q vdd gnd DFFSR
X_3895_ _3895_/D _4071_/CLK _3895_/Q vdd gnd DFFPOSX1
XFILL_0__3405_ vdd gnd FILL
X_2846_ _3971_/Q _3969_/Q _2994_/S _2848_/B vdd gnd MUX2X1
X_2777_ _2777_/A _2777_/B _2777_/C _4009_/D vdd gnd AOI21X1
XFILL_0__3198_ vdd gnd FILL
XFILL_0__2218_ vdd gnd FILL
X_3329_ _3358_/B _3352_/B vdd gnd INVX1
XFILL_1__2189_ vdd gnd FILL
XBUFX2_insert118 _1966_/Y _2165_/S vdd gnd BUFX2
XBUFX2_insert107 _1960_/Y _2175_/A vdd gnd BUFX2
XFILL_0__3121_ vdd gnd FILL
X_2631_ _3835_/Q _3117_/C vdd gnd INVX1
X_2562_ _2562_/A _2562_/B _2562_/C _2573_/A vdd gnd NAND3X1
X_2700_ _3136_/B _4050_/Q _4017_/Q _2701_/A vdd gnd NAND3X1
XFILL_0__3052_ vdd gnd FILL
X_3680_ _3681_/C _3680_/B _3680_/C _3680_/D _3875_/D vdd gnd OAI22X1
X_2493_ _2493_/A _2594_/A _2493_/C _2494_/C vdd gnd AOI21X1
XFILL_0__2905_ vdd gnd FILL
X_4163_ _4163_/D _4183_/CLK _4163_/Q vdd gnd DFFPOSX1
X_3114_ _3114_/A _3121_/A _3837_/D vdd gnd NOR2X1
X_3045_ _3827_/Q _3135_/A vdd gnd INVX1
XFILL_0__2698_ vdd gnd FILL
X_4094_ _4094_/D _4094_/CLK _4094_/Q vdd gnd DFFPOSX1
X_3878_ _3878_/D _4019_/CLK _3878_/Q vdd gnd DFFPOSX1
XFILL_1__3092_ vdd gnd FILL
XFILL_0__3319_ vdd gnd FILL
X_3947_ vdd _3947_/S _3947_/D _4121_/D _3947_/Q vdd gnd DFFSR
X_2829_ _2829_/A _2997_/B _3983_/D vdd gnd AND2X2
XFILL_1__2876_ vdd gnd FILL
XFILL_0__2552_ vdd gnd FILL
XFILL_0__2621_ vdd gnd FILL
XBUFX2_insert7 _2390_/Y _3448_/S vdd gnd BUFX2
X_3801_ _3801_/A _3801_/B _3801_/C _3802_/C vdd gnd OAI21X1
X_3732_ _3732_/A _3732_/B _3755_/S _3832_/D vdd gnd MUX2X1
X_1993_ _1993_/A _1993_/B _2645_/A _1995_/C vdd gnd OAI21X1
XFILL_0__3035_ vdd gnd FILL
X_2545_ _4064_/Q _2545_/B _2545_/C _2549_/A vdd gnd NAND3X1
X_2614_ _3863_/Q _3865_/Q _2615_/B vdd gnd NOR2X1
X_3594_ _3996_/Q _3595_/A _3595_/C vdd gnd NOR2X1
X_3663_ _3907_/Q _3666_/C vdd gnd INVX1
X_2476_ _3882_/Q _2509_/B _2476_/C _2586_/A vdd gnd OAI21X1
XFILL_0__2819_ vdd gnd FILL
XFILL_1__2661_ vdd gnd FILL
XFILL_0__3799_ vdd gnd FILL
X_4146_ _4146_/D _4146_/CLK _4146_/Q vdd gnd DFFPOSX1
X_3028_ _3028_/A _3136_/B _3884_/D vdd gnd AND2X2
X_4077_ _4077_/D _4084_/CLK _4077_/Q vdd gnd DFFPOSX1
XFILL_1__2026_ vdd gnd FILL
XFILL_1__2859_ vdd gnd FILL
XBUFX2_insert91 _3860_/Y _3071_/C vdd gnd BUFX2
XBUFX2_insert80 _2622_/Y _3309_/B vdd gnd BUFX2
X_2330_ _3870_/Q _2543_/B _2685_/S _2521_/A _2602_/A vdd gnd AOI22X1
X_2261_ _4192_/Q _3196_/A vdd gnd INVX1
XFILL_0__3653_ vdd gnd FILL
XFILL_0__3722_ vdd gnd FILL
X_4000_ _4000_/D _4036_/CLK _4000_/Q vdd gnd DFFPOSX1
X_2192_ _4112_/Q _3974_/Q _2652_/S _2193_/B vdd gnd MUX2X1
XFILL_0__2535_ vdd gnd FILL
X_3715_ _4078_/Q _3715_/B _3717_/A vdd gnd NOR2X1
X_1976_ _3221_/D _1976_/B _1976_/C _1976_/D _1977_/A vdd gnd OAI22X1
X_2528_ _4074_/Q _2586_/A _2594_/A _2538_/C _2529_/C vdd gnd AOI22X1
XFILL_1__2713_ vdd gnd FILL
X_3646_ _3648_/C _3672_/B _3646_/C _3672_/D _3945_/D vdd gnd OAI22X1
X_3577_ _3597_/A _4006_/Q _3577_/C _3579_/B vdd gnd OAI21X1
X_4129_ _4129_/D _4173_/CLK _4129_/Q vdd gnd DFFPOSX1
X_2459_ _2459_/A _3691_/A _3145_/A vdd gnd NAND2X1
XFILL_1__3127_ vdd gnd FILL
XFILL_1__2009_ vdd gnd FILL
XFILL132150x118950 vdd gnd FILL
XFILL_0__2251_ vdd gnd FILL
X_3500_ _3519_/A _3508_/B _3501_/A vdd gnd NAND2X1
XCLKBUF1_insert69 i_clk_fast _4183_/CLK vdd gnd CLKBUF1
X_2313_ _2313_/A _3691_/C _2685_/B vdd gnd NOR2X1
X_3362_ _3798_/A _3816_/A _3363_/C vdd gnd NAND2X1
X_3431_ _4080_/Q _3434_/B vdd gnd INVX1
X_2244_ _2244_/A _2498_/C _2244_/Y vdd gnd NOR2X1
X_3293_ _3363_/B _3730_/A _3294_/C vdd gnd NAND2X1
XFILL_0__3567_ vdd gnd FILL
XFILL_0__3636_ vdd gnd FILL
X_2175_ _2175_/A _2175_/B _2175_/C _2176_/A vdd gnd OAI21X1
XFILL_0__2518_ vdd gnd FILL
XFILL_1__2291_ vdd gnd FILL
XFILL_0__2449_ vdd gnd FILL
X_1959_ _4097_/Q _1975_/B vdd gnd INVX1
X_3629_ _3629_/A _3629_/Y vdd gnd INVX8
XFILL132750x86550 vdd gnd FILL
XFILL132150x82950 vdd gnd FILL
XFILL_1__3814_ vdd gnd FILL
XFILL_1__2489_ vdd gnd FILL
XFILL_0__3352_ vdd gnd FILL
X_2931_ _3932_/Q _2988_/A _2932_/C vdd gnd NAND2X1
XFILL_0__3283_ vdd gnd FILL
X_3980_ _3980_/D _4193_/CLK _3980_/Q vdd gnd DFFPOSX1
X_2862_ _3963_/Q _3960_/Q _2878_/S _2864_/B vdd gnd MUX2X1
X_2793_ _2793_/A _3009_/B _4001_/D vdd gnd AND2X2
XFILL_0__2165_ vdd gnd FILL
XFILL_0__2998_ vdd gnd FILL
X_3345_ _3345_/A _3345_/B _3345_/C _3346_/A vdd gnd NAND3X1
X_3276_ _3276_/A _3905_/Y _3277_/B vdd gnd AND2X2
X_3414_ _3416_/B _3414_/B _3446_/S _4100_/D vdd gnd MUX2X1
XFILL_0__1949_ vdd gnd FILL
X_2158_ _2158_/A _4118_/Q _2158_/S _2159_/B vdd gnd MUX2X1
X_2089_ _3744_/B _2152_/B _2092_/B vdd gnd NOR2X1
XFILL132750x18150 vdd gnd FILL
X_2227_ _2227_/A _2227_/B _2227_/C _2229_/C vdd gnd OAI21X1
XFILL132750x61350 vdd gnd FILL
XFILL_0__2852_ vdd gnd FILL
X_3130_ _3130_/A _3369_/A _3324_/C vdd gnd NAND2X1
X_3061_ _3152_/A _3061_/B _3926_/A _3863_/D vdd gnd AOI21X1
X_2012_ _4069_/Q _3891_/Q _2165_/S _2013_/B vdd gnd MUX2X1
X_3963_ _3963_/D _3977_/CLK _3963_/Q vdd gnd DFFPOSX1
X_2845_ _2845_/A _2885_/B _3975_/D vdd gnd AND2X2
X_3894_ _3894_/D _3908_/CLK _3894_/Q vdd gnd DFFPOSX1
X_2914_ _3938_/Q _3936_/Q _3006_/S _2916_/B vdd gnd MUX2X1
XFILL_0__3266_ vdd gnd FILL
XFILL_1__1912_ vdd gnd FILL
X_2776_ _4009_/Q _2776_/B _3947_/S _2777_/C vdd gnd OAI21X1
XFILL_0__2148_ vdd gnd FILL
XFILL_0__2079_ vdd gnd FILL
X_3328_ _3478_/C _3328_/B _3358_/B vdd gnd NAND2X1
X_3259_ _4168_/Q _3261_/A vdd gnd INVX1
XFILL_1__2326_ vdd gnd FILL
XFILL_1__3444_ vdd gnd FILL
XBUFX2_insert108 _1960_/Y _2157_/A vdd gnd BUFX2
XBUFX2_insert119 _1966_/Y _3221_/D vdd gnd BUFX2
XFILL_0__3120_ vdd gnd FILL
X_2492_ _2492_/A _2594_/A vdd gnd INVX1
X_2561_ _4079_/Q _2562_/B vdd gnd INVX1
X_2630_ _3033_/A _3106_/A _3110_/A vdd gnd NOR2X1
XFILL_0__2002_ vdd gnd FILL
X_3113_ _3837_/Q _3113_/B _3115_/B _3114_/A vdd gnd OAI21X1
XFILL_0__2835_ vdd gnd FILL
X_4093_ _4093_/D _4101_/CLK _4093_/Q vdd gnd DFFPOSX1
X_4162_ _4162_/D _4191_/CLK _4162_/Q vdd gnd DFFPOSX1
XFILL_0__2766_ vdd gnd FILL
X_3044_ _3049_/B _3044_/B _3044_/C _3872_/D vdd gnd AOI21X1
X_3946_ _3946_/D _3987_/CLK _3946_/Q vdd gnd DFFPOSX1
X_2828_ _2843_/B _2828_/B _2828_/C _2829_/A vdd gnd OAI21X1
X_3877_ _3901_/A vdd _3877_/D _4189_/CLK _3877_/Q vdd gnd DFFSR
X_2759_ _3038_/C _3048_/B _2760_/A _4017_/D vdd gnd OAI21X1
XFILL_1__3427_ vdd gnd FILL
XFILL_0__2482_ vdd gnd FILL
XBUFX2_insert8 _2390_/Y _3430_/S vdd gnd BUFX2
XFILL_0__3103_ vdd gnd FILL
X_3731_ _3731_/A _3731_/B _3747_/S _3834_/D vdd gnd MUX2X1
X_3800_ _3800_/A _3801_/C vdd gnd INVX1
X_3662_ _3664_/C _3662_/B _3662_/C _3662_/D _3911_/D vdd gnd OAI22X1
X_1992_ _1992_/A _2172_/B _1993_/A vdd gnd NOR2X1
X_2544_ _2544_/A _2685_/S _2545_/C vdd gnd NAND2X1
X_2475_ _3807_/A _2509_/B _2476_/C vdd gnd NAND2X1
X_2613_ _3859_/Q _3861_/Q _2615_/A vdd gnd NOR2X1
X_3593_ _3593_/A _3998_/Q _3593_/C _3595_/B vdd gnd OAI21X1
XFILL_0__2749_ vdd gnd FILL
X_4076_ _4076_/D _2244_/A _4076_/Q vdd gnd DFFPOSX1
X_4145_ _4145_/D _4147_/CLK _4145_/Q vdd gnd DFFPOSX1
XFILL_1_BUFX2_insert78 vdd gnd FILL
XFILL_0__3798_ vdd gnd FILL
XFILL_1_BUFX2_insert56 vdd gnd FILL
XFILL_1_BUFX2_insert34 vdd gnd FILL
XFILL_1_BUFX2_insert12 vdd gnd FILL
X_3027_ _3027_/A _3027_/B _3027_/C _3028_/A vdd gnd OAI21X1
X_3929_ _3929_/D _4184_/CLK _3929_/Q vdd gnd DFFPOSX1
XFILL_1__3074_ vdd gnd FILL
XBUFX2_insert92 _3860_/Y _3038_/C vdd gnd BUFX2
XBUFX2_insert81 _2622_/Y _3310_/B vdd gnd BUFX2
XBUFX2_insert70 _4176_/Q _3620_/A vdd gnd BUFX2
XFILL_0__1982_ vdd gnd FILL
XFILL_0__2603_ vdd gnd FILL
X_2260_ _4179_/Q _4188_/Q _2346_/A vdd gnd NOR2X1
XFILL_0__3583_ vdd gnd FILL
X_2191_ _2191_/A _2191_/B _2227_/C _2193_/C vdd gnd OAI21X1
XFILL_0__2465_ vdd gnd FILL
XFILL_0__2396_ vdd gnd FILL
XFILL_0__3017_ vdd gnd FILL
X_3645_ _3945_/Q _3648_/C vdd gnd INVX1
X_1975_ _4048_/Q _1975_/B _3875_/Q _1976_/B vdd gnd OAI21X1
X_3714_ _4046_/Q _3714_/B _3714_/C _3719_/A vdd gnd OAI21X1
X_2527_ _4068_/Q _2538_/C vdd gnd INVX1
X_2458_ _3690_/A _2458_/B _2458_/C _2459_/A vdd gnd OAI21X1
XFILL_1__3761_ vdd gnd FILL
X_3576_ _3597_/A _3747_/B _3577_/C vdd gnd NAND2X1
X_2389_ _2389_/A _2400_/C vdd gnd INVX1
X_4128_ _4128_/D _4146_/CLK _4128_/Q vdd gnd DFFPOSX1
XFILL_1__2643_ vdd gnd FILL
X_4059_ _4059_/D _4200_/CLK _4059_/Q vdd gnd DFFPOSX1
XFILL_1__3057_ vdd gnd FILL
XFILL_0__2181_ vdd gnd FILL
X_2312_ _2312_/A _2312_/B _3327_/A _2313_/A vdd gnd OAI21X1
X_3361_ _3844_/Q _3816_/A vdd gnd INVX1
X_3292_ _3836_/Q _3730_/A vdd gnd INVX1
X_3430_ _3432_/B _3430_/B _3430_/S _4082_/D vdd gnd MUX2X1
XFILL_0__1965_ vdd gnd FILL
XFILL_0__3704_ vdd gnd FILL
XFILL_0__2517_ vdd gnd FILL
X_2243_ _4087_/Q _2498_/C vdd gnd INVX1
X_2174_ _4108_/Q _3966_/Q _2652_/S _2175_/B vdd gnd MUX2X1
XFILL_0__2379_ vdd gnd FILL
XFILL_0__3497_ vdd gnd FILL
X_1958_ _1958_/A _3715_/B _1958_/C _1964_/A vdd gnd AOI21X1
X_3628_ _3867_/Q _3683_/A vdd gnd INVX1
XFILL_1__3744_ vdd gnd FILL
X_3559_ _3611_/A _3559_/B _3559_/C _4018_/D vdd gnd AOI21X1
XFILL_0__3420_ vdd gnd FILL
X_2861_ _2861_/A _3009_/B _3967_/D vdd gnd AND2X2
XFILL_0__2302_ vdd gnd FILL
X_2930_ _3929_/Q _3927_/Q _2950_/S _2932_/B vdd gnd MUX2X1
XFILL_0__2233_ vdd gnd FILL
X_2792_ _2796_/A _2792_/B _2792_/C _2793_/A vdd gnd OAI21X1
X_3413_ _4100_/Q _3416_/B vdd gnd INVX1
XFILL_0__2095_ vdd gnd FILL
XFILL_0__2997_ vdd gnd FILL
X_3344_ _3344_/A _3352_/B _3344_/C _3345_/B vdd gnd NAND3X1
X_3275_ _3275_/A _3373_/B vdd gnd INVX1
XFILL_1_BUFX2_insert8 vdd gnd FILL
X_2226_ _2226_/A _2650_/B _2227_/A vdd gnd NOR2X1
XFILL_1__3391_ vdd gnd FILL
XFILL_1__2273_ vdd gnd FILL
X_2157_ _2157_/A _2157_/B _2157_/C _2158_/A vdd gnd OAI21X1
X_2088_ _4134_/Q _3744_/B vdd gnd INVX1
XFILL_0__3618_ vdd gnd FILL
XFILL_0_BUFX2_insert91 vdd gnd FILL
XFILL_0_BUFX2_insert80 vdd gnd FILL
XFILL_0__2920_ vdd gnd FILL
XFILL_0__2782_ vdd gnd FILL
X_3060_ _3067_/B _3060_/B _3061_/B vdd gnd AND2X2
XFILL132750x122550 vdd gnd FILL
XFILL_0__3334_ vdd gnd FILL
X_2011_ _2011_/A _2011_/B _2175_/A _2013_/C vdd gnd OAI21X1
XFILL_0__3403_ vdd gnd FILL
X_2844_ _2864_/A _2844_/B _2844_/C _2845_/A vdd gnd OAI21X1
X_2913_ _2913_/A _3976_/R _3942_/D vdd gnd AND2X2
X_3962_ _3962_/D _4040_/CLK _3962_/Q vdd gnd DFFPOSX1
XFILL_0__3196_ vdd gnd FILL
X_3893_ _3893_/D _4101_/CLK _3893_/Q vdd gnd DFFPOSX1
XFILL_0__2147_ vdd gnd FILL
XFILL_0__2216_ vdd gnd FILL
XFILL_1__2960_ vdd gnd FILL
X_2775_ _2950_/S _2778_/B _2777_/A vdd gnd NAND2X1
X_3327_ _3327_/A _3328_/B vdd gnd INVX1
X_3258_ _3258_/A _3370_/B _3258_/C _3258_/D _4170_/D vdd gnd AOI22X1
X_3189_ _3286_/A _3744_/A _3190_/C vdd gnd NAND2X1
X_2209_ _2209_/A _2209_/B _2653_/A _2211_/C vdd gnd OAI21X1
XFILL_1__3374_ vdd gnd FILL
XBUFX2_insert109 _1960_/Y _2155_/C vdd gnd BUFX2
XFILL_0__3050_ vdd gnd FILL
X_2560_ i_rf_miso _2571_/A vdd gnd INVX1
X_2491_ _3876_/Q _2509_/B _2491_/C _2492_/A vdd gnd OAI21X1
XFILL_0__2903_ vdd gnd FILL
X_3112_ _3112_/A _3115_/B vdd gnd INVX1
X_4092_ _4092_/D _2244_/A _4092_/Q vdd gnd DFFPOSX1
XFILL_0__2834_ vdd gnd FILL
X_3043_ _3872_/Q _3049_/B _3136_/B _3044_/C vdd gnd OAI21X1
XFILL_0__2696_ vdd gnd FILL
X_4161_ _4161_/D _3214_/A _4161_/Q vdd gnd DFFPOSX1
XFILL_0__3317_ vdd gnd FILL
X_3945_ _3945_/D _3961_/CLK _3945_/Q vdd gnd DFFPOSX1
XFILL_1__2110_ vdd gnd FILL
X_3876_ _3876_/D _4019_/CLK _3876_/Q vdd gnd DFFPOSX1
X_2758_ _2758_/A _3035_/B _2760_/A vdd gnd NAND2X1
X_2827_ _3983_/Q _2827_/B _2828_/C vdd gnd NAND2X1
XFILL_0__3248_ vdd gnd FILL
X_2689_ _2689_/A _3901_/A _4033_/D vdd gnd AND2X2
XFILL_1__2308_ vdd gnd FILL
XFILL_0__2550_ vdd gnd FILL
XFILL131850x86550 vdd gnd FILL
XFILL131550x118950 vdd gnd FILL
XBUFX2_insert9 _2390_/Y _3446_/S vdd gnd BUFX2
XFILL_0__3033_ vdd gnd FILL
X_2612_ _3857_/Q _3072_/A vdd gnd INVX1
X_3730_ _3730_/A _3730_/B _3747_/S _3836_/D vdd gnd MUX2X1
X_3661_ _3911_/Q _3664_/C vdd gnd INVX1
X_1991_ _3718_/A _3990_/Q _1992_/A vdd gnd NAND2X1
X_3592_ _3620_/A _3751_/B _3593_/C vdd gnd NAND2X1
X_2543_ _3872_/Q _2543_/B _2545_/B vdd gnd NAND2X1
X_2474_ _3855_/Q _3807_/A vdd gnd INVX1
XFILL_1__2590_ vdd gnd FILL
X_3026_ _3884_/Q _3027_/A _3027_/C vdd gnd NAND2X1
XFILL_0__2817_ vdd gnd FILL
X_4075_ _4075_/D _4084_/CLK _4075_/Q vdd gnd DFFPOSX1
X_4144_ _4144_/D _4157_/CLK _4144_/Q vdd gnd DFFPOSX1
XFILL_1__3211_ vdd gnd FILL
X_3928_ _3928_/D _4094_/CLK _3928_/Q vdd gnd DFFPOSX1
XFILL_1_CLKBUF1_insert69 vdd gnd FILL
X_3859_ _3859_/D _4039_/CLK _3859_/Q vdd gnd DFFPOSX1
XFILL_1__2788_ vdd gnd FILL
XFILL_1__3409_ vdd gnd FILL
XFILL131850x61350 vdd gnd FILL
XBUFX2_insert60 _3143_/Y _3680_/B vdd gnd BUFX2
XBUFX2_insert82 _2622_/Y _3245_/B vdd gnd BUFX2
XFILL_0__3720_ vdd gnd FILL
XBUFX2_insert93 _3860_/Y _3771_/A vdd gnd BUFX2
XBUFX2_insert71 _4176_/Q _3617_/A vdd gnd BUFX2
XFILL_0__2533_ vdd gnd FILL
XFILL_0__3651_ vdd gnd FILL
X_2190_ _2190_/A _2650_/B _2191_/A vdd gnd NOR2X1
XFILL_0__2464_ vdd gnd FILL
X_1974_ _4161_/Q _1974_/B _2172_/B _1976_/D vdd gnd MUX2X1
X_3644_ _3646_/C _3672_/B _3644_/C _3672_/D _3949_/D vdd gnd OAI22X1
X_3575_ _3599_/A _3575_/B _3575_/C _4006_/D vdd gnd AOI21X1
X_3713_ _3714_/B _3713_/B _3716_/C _3714_/C vdd gnd AOI21X1
X_2526_ _2592_/A _4070_/Q _2529_/B vdd gnd OR2X2
X_2388_ _4196_/Q _3487_/B _2389_/A vdd gnd NAND2X1
XFILL_1__3691_ vdd gnd FILL
X_2457_ _2457_/A _3691_/A vdd gnd INVX1
X_4058_ _4058_/D _4089_/CLK _4058_/Q vdd gnd DFFPOSX1
X_3009_ _3009_/A _3009_/B _3892_/D vdd gnd AND2X2
X_4127_ _4127_/D _4189_/CLK _4127_/Q vdd gnd DFFPOSX1
XFILL132750x46950 vdd gnd FILL
X_2311_ _2402_/B _3314_/C _3905_/Y _3327_/A vdd gnd OAI21X1
X_3291_ _3385_/B _3291_/B _3291_/C _4156_/D vdd gnd AOI21X1
X_3360_ _4131_/Q _3364_/A _3364_/C vdd gnd NAND2X1
X_2242_ _3773_/Y _2643_/A _3771_/A _4097_/D vdd gnd AOI21X1
XFILL_0__3565_ vdd gnd FILL
XFILL_0__3634_ vdd gnd FILL
X_2173_ _2173_/A _2173_/B _2175_/A _2175_/C vdd gnd OAI21X1
XFILL_0__2447_ vdd gnd FILL
X_1957_ _3618_/B _2172_/B _3718_/A _1965_/A vdd gnd OAI21X1
X_2509_ _3809_/A _2509_/B _4093_/Q _2552_/A vdd gnd AOI21X1
X_3558_ _4018_/Q _3611_/A _3559_/C vdd gnd NOR2X1
XFILL132750x21750 vdd gnd FILL
X_3627_ _3978_/Q _3632_/C vdd gnd INVX1
XFILL_1__2625_ vdd gnd FILL
X_3489_ _3489_/A _3526_/S _3491_/C vdd gnd AND2X2
XFILL_1__3039_ vdd gnd FILL
XFILL_0__2301_ vdd gnd FILL
XFILL_0__3350_ vdd gnd FILL
X_2860_ _2900_/B _2860_/B _2860_/C _2861_/A vdd gnd OAI21X1
X_2791_ _4001_/Q _2796_/A _2792_/C vdd gnd NAND2X1
XFILL_0__3281_ vdd gnd FILL
XFILL_0_CLKBUF1_insert190 vdd gnd FILL
XFILL_0__2163_ vdd gnd FILL
X_3412_ _3414_/B _3412_/B _3446_/S _4102_/D vdd gnd MUX2X1
X_3343_ _3343_/A _3369_/A _3345_/A vdd gnd NAND2X1
XFILL_1__2410_ vdd gnd FILL
X_3274_ _3913_/Y _3382_/B _3275_/A vdd gnd NAND2X1
XFILL_0__1947_ vdd gnd FILL
X_2225_ _2649_/A _4049_/Q _2226_/A vdd gnd NAND2X1
XFILL_0__3479_ vdd gnd FILL
XFILL_0__3548_ vdd gnd FILL
X_2156_ _4104_/Q _3957_/Q _2165_/S _2157_/B vdd gnd MUX2X1
X_2087_ _2655_/A _2087_/B _4134_/D vdd gnd NOR2X1
X_2989_ _2989_/A _2997_/B _3902_/D vdd gnd AND2X2
XFILL132450x68550 vdd gnd FILL
XFILL_1__3726_ vdd gnd FILL
XFILL_1__1987_ vdd gnd FILL
XFILL_1__2608_ vdd gnd FILL
XFILL_0_BUFX2_insert81 vdd gnd FILL
XFILL_0__2781_ vdd gnd FILL
XFILL_0__2850_ vdd gnd FILL
X_2010_ _2010_/A _2163_/B _2011_/A vdd gnd NOR2X1
X_2912_ _3027_/A _2912_/B _2912_/C _2913_/A vdd gnd OAI21X1
XFILL_0__3264_ vdd gnd FILL
X_3961_ _3961_/D _3961_/CLK _3961_/Q vdd gnd DFFPOSX1
XFILL_0__3402_ vdd gnd FILL
X_2843_ _3975_/Q _2843_/B _2844_/C vdd gnd NAND2X1
X_3892_ _3892_/D _3997_/CLK _3892_/Q vdd gnd DFFPOSX1
X_2774_ _4009_/Q _2774_/B _2777_/B vdd gnd NAND2X1
XFILL_0__3195_ vdd gnd FILL
XFILL_0__2077_ vdd gnd FILL
X_3326_ _3326_/A _3388_/A _3326_/C _3326_/D _4141_/D vdd gnd AOI22X1
X_3257_ _4172_/Q _3272_/B _3391_/S _3258_/D vdd gnd OAI21X1
X_3188_ _4180_/Q _3744_/A vdd gnd INVX1
X_2139_ _2155_/C _2139_/B _2139_/C _2140_/A vdd gnd OAI21X1
X_2208_ _2208_/A _2650_/B _2209_/A vdd gnd NOR2X1
XFILL_1__2255_ vdd gnd FILL
XFILL132450x43350 vdd gnd FILL
XFILL_0__2000_ vdd gnd FILL
X_2490_ _3807_/B _2509_/B _2491_/C vdd gnd NAND2X1
X_4160_ _4160_/D _4191_/CLK _4160_/Q vdd gnd DFFPOSX1
X_3111_ _3117_/A _3117_/B _3112_/A vdd gnd NOR2X1
X_4091_ _4091_/D _2244_/A _4091_/Q vdd gnd DFFPOSX1
X_3042_ _3829_/Q _3847_/Q _3841_/Q _3044_/B vdd gnd MUX2X1
XFILL_0__2764_ vdd gnd FILL
X_3944_ _3944_/D _4184_/CLK _3944_/Q vdd gnd DFFPOSX1
X_3875_ _3875_/D _4114_/CLK _3875_/Q vdd gnd DFFPOSX1
XFILL_1__2040_ vdd gnd FILL
X_2757_ _3107_/A _2757_/B _2757_/C _4019_/D vdd gnd AOI21X1
X_2826_ _3981_/Q _3979_/Q _2994_/S _2828_/B vdd gnd MUX2X1
XFILL_1__2942_ vdd gnd FILL
X_2688_ _3152_/A _2688_/B _3926_/A _4035_/D vdd gnd AOI21X1
XFILL_0__3178_ vdd gnd FILL
X_3309_ _3309_/A _3309_/B _3310_/C vdd gnd NAND2X1
XFILL_1__3356_ vdd gnd FILL
XFILL_1__2238_ vdd gnd FILL
XFILL_0__2480_ vdd gnd FILL
XFILL_0__3101_ vdd gnd FILL
X_1990_ _3756_/B _2170_/B _1993_/B vdd gnd NOR2X1
X_2611_ _4017_/Q _3103_/B vdd gnd INVX2
X_2542_ _4058_/Q _2606_/A _2542_/C _2550_/A vdd gnd OAI21X1
XFILL_0__3032_ vdd gnd FILL
X_3660_ _3662_/C _3662_/B _3660_/C _3662_/D _3915_/D vdd gnd OAI22X1
X_3591_ _3595_/A _3591_/B _3591_/C _3998_/D vdd gnd AOI21X1
X_2473_ _2589_/A _2478_/B vdd gnd INVX1
X_4143_ _4143_/D _4147_/CLK _4143_/Q vdd gnd DFFPOSX1
XFILL_1_BUFX2_insert25 vdd gnd FILL
XFILL_0__3796_ vdd gnd FILL
XFILL_1_BUFX2_insert47 vdd gnd FILL
XFILL_0__2747_ vdd gnd FILL
X_4074_ _4074_/D _4089_/CLK _4074_/Q vdd gnd DFFPOSX1
X_3025_ _4022_/Q _4024_/Q _3025_/S _3027_/B vdd gnd MUX2X1
XFILL_0__2678_ vdd gnd FILL
X_3927_ _3927_/D _4184_/CLK _3927_/Q vdd gnd DFFPOSX1
X_3858_ _3858_/D _3806_/A _3858_/Q vdd gnd DFFPOSX1
X_2809_ _2809_/A _3009_/B _3993_/D vdd gnd AND2X2
XFILL_1__2925_ vdd gnd FILL
X_3789_ _3789_/A _3789_/B _3881_/D vdd gnd AND2X2
XFILL_1__3339_ vdd gnd FILL
XBUFX2_insert83 _4032_/Q _2878_/S vdd gnd BUFX2
XBUFX2_insert50 _3856_/Q _3363_/B vdd gnd BUFX2
XBUFX2_insert72 _4176_/Q _3593_/A vdd gnd BUFX2
XBUFX2_insert61 _3143_/Y _3683_/B vdd gnd BUFX2
XFILL_0__1980_ vdd gnd FILL
XBUFX2_insert94 _3860_/Y _2655_/A vdd gnd BUFX2
XFILL_0__2601_ vdd gnd FILL
XFILL_0__3581_ vdd gnd FILL
XFILL_0__2394_ vdd gnd FILL
X_3712_ _3712_/A _3712_/B _3712_/C _3713_/B vdd gnd AOI21X1
X_1973_ _3710_/C _3614_/B _1974_/B vdd gnd NOR2X1
X_2525_ _4070_/Q _2592_/A _2529_/A vdd gnd NAND2X1
XFILL_0__3015_ vdd gnd FILL
X_3643_ _3949_/Q _3646_/C vdd gnd INVX1
X_3574_ _4006_/Q _3599_/A _3575_/C vdd gnd NOR2X1
XFILL_1__2572_ vdd gnd FILL
XFILL_0__3917_ vdd gnd FILL
X_2387_ _3237_/A _2387_/B _2390_/C vdd gnd NAND2X1
X_2456_ _2456_/A _2458_/C _2457_/A vdd gnd NOR2X1
XFILL_0__3779_ vdd gnd FILL
X_4126_ _4126_/D _4146_/CLK _4126_/Q vdd gnd DFFPOSX1
X_3008_ _3008_/A _3008_/B _3008_/C _3009_/A vdd gnd OAI21X1
X_4057_ _4057_/D _4196_/CLK _4057_/Q vdd gnd DFFPOSX1
X_3290_ _4156_/Q _3385_/B _3291_/C vdd gnd NOR2X1
X_2310_ _4188_/Q _3200_/A _3314_/C vdd gnd NOR2X1
XFILL_0__1963_ vdd gnd FILL
X_2172_ _2172_/A _2172_/B _2173_/A vdd gnd NOR2X1
XFILL_0__3702_ vdd gnd FILL
X_2241_ _3712_/B _3223_/B _2645_/A _2643_/A vdd gnd OAI21X1
XFILL_0__2515_ vdd gnd FILL
XFILL_0__3495_ vdd gnd FILL
XFILL_0__2377_ vdd gnd FILL
X_1956_ _1956_/A _3702_/A _1958_/A _1956_/Y vdd gnd NAND3X1
X_2508_ _2608_/B _2580_/B vdd gnd INVX1
X_3488_ _3488_/A _3488_/B _3488_/C _3489_/A vdd gnd OAI21X1
X_3557_ _3609_/A _4021_/Q _3557_/C _3559_/B vdd gnd OAI21X1
X_3626_ _3626_/A _3626_/B _3626_/C _3626_/D _3980_/D vdd gnd AOI22X1
XFILL_1__2555_ vdd gnd FILL
XFILL_1__3673_ vdd gnd FILL
X_4109_ _4109_/D _4148_/CLK _4109_/Q vdd gnd DFFPOSX1
X_2439_ _4021_/Q _3924_/Q _3709_/B _2440_/C vdd gnd NAND3X1
X_2790_ _3999_/Q _3997_/Q _3019_/A _2792_/B vdd gnd MUX2X1
XFILL_0_CLKBUF1_insert191 vdd gnd FILL
XFILL_0__2093_ vdd gnd FILL
XFILL_0__2231_ vdd gnd FILL
XFILL_0__2995_ vdd gnd FILL
X_3342_ _4142_/Q _3363_/B _3342_/C _3343_/A vdd gnd OAI21X1
X_3411_ _4102_/Q _3414_/B vdd gnd INVX1
X_3273_ _3273_/A _3370_/B _3326_/C _3273_/D _4160_/D vdd gnd AOI22X1
XFILL_0__3616_ vdd gnd FILL
X_2155_ _2155_/A _2155_/B _2155_/C _2157_/C vdd gnd OAI21X1
X_2224_ _3729_/B _2648_/B _2227_/B vdd gnd NOR2X1
XFILL_0__2429_ vdd gnd FILL
XFILL_0__3547_ vdd gnd FILL
X_2086_ _2086_/A _4134_/Q _2185_/S _2087_/B vdd gnd MUX2X1
X_2988_ _2988_/A _2988_/B _2988_/C _2989_/A vdd gnd OAI21X1
X_1939_ _1939_/A _3721_/B vdd gnd INVX1
X_3609_ _3609_/A _3990_/Q _3609_/C _3611_/B vdd gnd OAI21X1
XFILL_1__3656_ vdd gnd FILL
XFILL_0_BUFX2_insert93 vdd gnd FILL
XFILL_0_BUFX2_insert71 vdd gnd FILL
X_3960_ _3960_/D _3977_/CLK _3960_/Q vdd gnd DFFPOSX1
X_2911_ _3942_/Q _3027_/A _2912_/C vdd gnd NAND2X1
XFILL_0__3332_ vdd gnd FILL
XFILL_0__2214_ vdd gnd FILL
X_3891_ _3891_/D _3961_/CLK _3891_/Q vdd gnd DFFPOSX1
X_2842_ _3973_/Q _3971_/Q _2878_/S _2844_/B vdd gnd MUX2X1
X_2773_ _2773_/A _2773_/B _2773_/C _4011_/D vdd gnd AOI21X1
XFILL_0__2145_ vdd gnd FILL
XFILL_0__2978_ vdd gnd FILL
X_3325_ _4143_/Q _3325_/B _3344_/C _3326_/D vdd gnd OAI21X1
X_3256_ _4170_/Q _3258_/A vdd gnd INVX1
XFILL_1__3510_ vdd gnd FILL
X_2138_ _4100_/Q _3949_/Q _2165_/S _2139_/B vdd gnd MUX2X1
X_2207_ _2649_/A _4045_/Q _2208_/A vdd gnd NAND2X1
X_2069_ _2655_/A _2069_/B _4138_/D vdd gnd NOR2X1
X_3187_ _3926_/B _3187_/B _3187_/C _4194_/D vdd gnd OAI21X1
XFILL_1__2185_ vdd gnd FILL
XFILL_1__1969_ vdd gnd FILL
XFILL_1__3708_ vdd gnd FILL
X_3110_ _3110_/A _3117_/B vdd gnd INVX1
XFILL_0__2901_ vdd gnd FILL
XFILL_0__2832_ vdd gnd FILL
X_3041_ _3049_/B _3041_/B _3041_/C _3874_/D vdd gnd AOI21X1
XFILL_0__2694_ vdd gnd FILL
X_4090_ _4090_/D _4094_/CLK _4090_/Q vdd gnd DFFPOSX1
X_2825_ _2825_/A _2997_/B _3985_/D vdd gnd AND2X2
X_3874_ _3874_/D _4139_/CLK _3874_/Q vdd gnd DFFPOSX1
XFILL_0__3315_ vdd gnd FILL
XFILL_0__3246_ vdd gnd FILL
X_3943_ _4180_/R vdd _3943_/D _4182_/CLK _3943_/Q vdd gnd DFFSR
XFILL_1__2872_ vdd gnd FILL
X_2756_ _4019_/Q _3107_/A _3136_/B _2757_/C vdd gnd OAI21X1
X_2687_ _4035_/Q _3073_/S _2688_/B vdd gnd NAND2X1
XFILL_0__2059_ vdd gnd FILL
XFILL_0__2128_ vdd gnd FILL
X_3308_ _4109_/Q _3333_/A _3308_/C _3309_/A vdd gnd OAI21X1
X_3239_ _3239_/A _3239_/B _3240_/A vdd gnd NAND2X1
XFILL_1__3286_ vdd gnd FILL
XFILL132450x118950 vdd gnd FILL
X_2541_ _2541_/A _2541_/B _2542_/C vdd gnd NOR2X1
X_2472_ _3853_/Q _2607_/A _2472_/C _2589_/A vdd gnd OAI21X1
X_2610_ _4054_/Q _2620_/B vdd gnd INVX1
X_3590_ _3998_/Q _3595_/A _3591_/C vdd gnd NOR2X1
XFILL_0__2746_ vdd gnd FILL
XFILL_0__2815_ vdd gnd FILL
X_4073_ _4073_/D _4084_/CLK _4073_/Q vdd gnd DFFPOSX1
X_4142_ _4142_/D _4157_/CLK _4142_/Q vdd gnd DFFPOSX1
X_3024_ _3024_/A _3027_/A _3024_/C _3886_/D vdd gnd AOI21X1
XFILL_1__3140_ vdd gnd FILL
X_2808_ _2903_/A _2808_/B _2808_/C _2809_/A vdd gnd OAI21X1
X_3857_ _3857_/D _4199_/CLK _3857_/Q vdd gnd DFFPOSX1
X_3926_ _3926_/A _3926_/B _3926_/Y vdd gnd NOR2X1
XFILL_1__2022_ vdd gnd FILL
X_3788_ _3806_/A _3814_/A _3789_/A vdd gnd NAND2X1
X_2739_ _4026_/Q _3022_/B _2898_/C vdd gnd NAND2X1
XBUFX2_insert84 _4032_/Q _3019_/A vdd gnd BUFX2
XBUFX2_insert40 _2905_/Y _2972_/A vdd gnd BUFX2
XBUFX2_insert51 _3856_/Q _3333_/A vdd gnd BUFX2
XBUFX2_insert95 _3860_/Y _2177_/A vdd gnd BUFX2
XBUFX2_insert73 _4176_/Q _3625_/A vdd gnd BUFX2
XFILL_0__2531_ vdd gnd FILL
XFILL_0__2462_ vdd gnd FILL
X_3642_ _3644_/C _3672_/B _3642_/C _3672_/D _3953_/D vdd gnd OAI22X1
X_3711_ _3711_/A _3711_/B _3711_/C _3712_/C vdd gnd OAI21X1
X_1972_ _3986_/Q _3614_/B vdd gnd INVX1
X_2524_ _2524_/A _2524_/B _2551_/C vdd gnd NOR2X1
X_2455_ _2455_/A _2456_/A vdd gnd INVX1
X_3573_ _3597_/A _4008_/Q _3573_/C _3575_/B vdd gnd OAI21X1
X_4056_ _4056_/D _2244_/A _4056_/Q vdd gnd DFFPOSX1
XFILL_0__2729_ vdd gnd FILL
X_4125_ _4125_/D _4172_/CLK _4125_/Q vdd gnd DFFPOSX1
X_2386_ _3909_/Y _4190_/Q _3479_/B _2397_/B vdd gnd OAI21X1
X_3007_ _3892_/Q _3008_/A _3008_/C vdd gnd NAND2X1
XFILL_1__3123_ vdd gnd FILL
X_3909_ _4179_/Q _3909_/Y vdd gnd INVX1
XFILL_1__2907_ vdd gnd FILL
XFILL_0__1962_ vdd gnd FILL
XFILL_0__3563_ vdd gnd FILL
XFILL_0__3632_ vdd gnd FILL
X_2171_ _2171_/A _3982_/Q _2172_/A vdd gnd NAND2X1
X_2240_ _2655_/A _2240_/B _4099_/D vdd gnd NOR2X1
XFILL_0__2376_ vdd gnd FILL
XFILL_0__2445_ vdd gnd FILL
X_1955_ _4171_/Q _3712_/B _3702_/A vdd gnd NOR2X1
X_3625_ _3625_/A _4046_/Q _3626_/B _3626_/C vdd gnd AOI21X1
X_2507_ _2507_/A _3901_/A _4095_/D vdd gnd AND2X2
XFILL_1__3810_ vdd gnd FILL
X_3487_ _3487_/A _3487_/B _3487_/C _3488_/B vdd gnd NAND3X1
X_3556_ _3597_/A _3742_/B _3557_/C vdd gnd NAND2X1
XFILL132450x28950 vdd gnd FILL
X_2438_ _4000_/Q _4061_/Q _2440_/B vdd gnd NAND2X1
X_4039_ _4039_/D _4039_/CLK _4039_/Q vdd gnd DFFPOSX1
X_2369_ _2370_/B _2370_/A _3689_/B vdd gnd OR2X2
X_4108_ _4108_/D _4114_/CLK _4108_/Q vdd gnd DFFPOSX1
XFILL_0__2161_ vdd gnd FILL
X_3272_ _4162_/Q _3272_/B _3364_/A _3273_/D vdd gnd OAI21X1
X_3341_ _3798_/A _3748_/A _3342_/C vdd gnd NAND2X1
X_3410_ _3412_/B _3410_/B _3446_/S _4104_/D vdd gnd MUX2X1
XFILL_0__1945_ vdd gnd FILL
X_2223_ _4103_/Q _3729_/B vdd gnd INVX1
X_2154_ _2154_/A _2154_/B _2155_/A vdd gnd NOR2X1
X_2085_ _2227_/C _2085_/B _2085_/C _2086_/A vdd gnd OAI21X1
X_2987_ _3902_/Q _2988_/A _2988_/C vdd gnd NAND2X1
XFILL_0__2359_ vdd gnd FILL
XFILL_0__3477_ vdd gnd FILL
X_1938_ _4163_/Q _1958_/C vdd gnd INVX1
X_3608_ _3609_/A _3756_/B _3609_/C vdd gnd NAND2X1
X_3539_ _3603_/A _3539_/B _3539_/C _4029_/D vdd gnd AOI21X1
XFILL_1__2537_ vdd gnd FILL
XFILL_0_BUFX2_insert83 vdd gnd FILL
XFILL_0_BUFX2_insert50 vdd gnd FILL
XFILL_0_BUFX2_insert72 vdd gnd FILL
XFILL_0_BUFX2_insert61 vdd gnd FILL
XFILL_0_BUFX2_insert94 vdd gnd FILL
XFILL_0__3400_ vdd gnd FILL
X_2841_ _2841_/A _2885_/B _3977_/D vdd gnd AND2X2
X_3890_ _3890_/D _4003_/CLK _3890_/Q vdd gnd DFFPOSX1
X_2910_ _3940_/Q _3938_/Q _3006_/S _2912_/B vdd gnd MUX2X1
XFILL_0__3262_ vdd gnd FILL
XFILL_0__3193_ vdd gnd FILL
XFILL_0__2213_ vdd gnd FILL
X_2772_ _4011_/Q _4013_/Q _4197_/R _2773_/C vdd gnd OAI21X1
XFILL_0__2075_ vdd gnd FILL
X_3324_ _3324_/A _3388_/A _3324_/C _3324_/D _4143_/D vdd gnd AOI22X1
X_3255_ _3255_/A _3370_/B _3255_/C _3255_/D _4172_/D vdd gnd AOI22X1
XFILL_0__1928_ vdd gnd FILL
XFILL_1__3440_ vdd gnd FILL
X_2206_ _3731_/B _2648_/B _2209_/B vdd gnd NOR2X1
X_3186_ _3186_/A _3245_/B _3688_/B _3187_/C vdd gnd OAI21X1
X_2137_ _2137_/A _2137_/B _2155_/C _2139_/C vdd gnd OAI21X1
X_2068_ _2068_/A _4138_/Q _2185_/S _2069_/B vdd gnd MUX2X1
XFILL132750x97350 vdd gnd FILL
XFILL132150x93750 vdd gnd FILL
XFILL_1__3638_ vdd gnd FILL
XFILL_0__2900_ vdd gnd FILL
XFILL132750x150 vdd gnd FILL
XFILL_0__2762_ vdd gnd FILL
X_3040_ _3874_/Q _3049_/B _3136_/B _3041_/C vdd gnd OAI21X1
XFILL_0__3314_ vdd gnd FILL
XFILL_0__2693_ vdd gnd FILL
X_2824_ _2827_/B _2824_/B _2824_/C _2825_/A vdd gnd OAI21X1
X_3942_ _3942_/D _4003_/CLK _3942_/Q vdd gnd DFFPOSX1
XFILL_0__3176_ vdd gnd FILL
X_3873_ _4196_/Q _3913_/Y _3897_/A vdd gnd NAND2X1
X_2755_ _4052_/Q _4044_/Q _3841_/Q _2757_/B vdd gnd MUX2X1
X_2686_ _3071_/C _2686_/B _4037_/D vdd gnd NOR2X1
X_3238_ _3238_/A _3351_/B _3326_/C _4177_/D vdd gnd OAI21X1
X_3169_ _3170_/A _3169_/B _3169_/C _3176_/A vdd gnd AOI21X1
X_3307_ _3333_/A _3732_/A _3308_/C vdd gnd NAND2X1
XFILL132750x72150 vdd gnd FILL
XFILL_1__2167_ vdd gnd FILL
XFILL_0__3030_ vdd gnd FILL
X_2540_ _2540_/A _2540_/B _2540_/C _2541_/B vdd gnd NAND3X1
X_2471_ _2509_/B _3880_/Q _2472_/C vdd gnd OR2X2
X_4072_ _4072_/D _2244_/A _4072_/Q vdd gnd DFFPOSX1
X_3023_ _3023_/A _3027_/A _3136_/B _3024_/C vdd gnd OAI21X1
X_4141_ _4141_/D _4191_/CLK _4141_/Q vdd gnd DFFPOSX1
XFILL_0__2676_ vdd gnd FILL
XFILL_0__3794_ vdd gnd FILL
XFILL_1__3070_ vdd gnd FILL
X_3925_ _3925_/D _4032_/CLK _3925_/Q vdd gnd DFFPOSX1
X_2738_ _3025_/S _2895_/B _2748_/C _2742_/A vdd gnd OAI21X1
X_2807_ _3993_/Q _2903_/A _2808_/C vdd gnd NAND2X1
X_3856_ _3947_/S vdd _3856_/D _4197_/CLK _3856_/Q vdd gnd DFFSR
XFILL_0__3228_ vdd gnd FILL
X_3787_ _3787_/A _3787_/B _3814_/A vdd gnd NOR2X1
XFILL_1__2854_ vdd gnd FILL
X_2669_ _2669_/A _2669_/B _3077_/C _4042_/D vdd gnd AOI21X1
XFILL_1__3268_ vdd gnd FILL
XBUFX2_insert85 _4032_/Q _3025_/S vdd gnd BUFX2
XBUFX2_insert41 _2905_/Y _2992_/A vdd gnd BUFX2
XBUFX2_insert30 i_rst_n _4201_/R vdd gnd BUFX2
XBUFX2_insert52 _3856_/Q _3235_/B vdd gnd BUFX2
XBUFX2_insert74 _4176_/Q _3605_/A vdd gnd BUFX2
XBUFX2_insert96 _3860_/Y _2186_/A vdd gnd BUFX2
XFILL_0__2530_ vdd gnd FILL
XFILL_0__2392_ vdd gnd FILL
XFILL_0__3013_ vdd gnd FILL
X_3641_ _3953_/Q _3644_/C vdd gnd INVX1
X_3572_ _3597_/A _3746_/B _3573_/C vdd gnd NAND2X1
X_3710_ _4171_/Q _4193_/Q _3710_/C _3711_/C vdd gnd AOI21X1
X_1971_ _3718_/A _3710_/C vdd gnd INVX1
X_2523_ _4066_/Q _2598_/A _2523_/C _2524_/B vdd gnd OAI21X1
X_2454_ _2458_/B _3690_/A _2455_/A vdd gnd NOR2X1
X_2385_ _4061_/Q _3709_/B vdd gnd INVX1
X_3006_ _3890_/Q _3888_/Q _3006_/S _3008_/B vdd gnd MUX2X1
XFILL_0__2659_ vdd gnd FILL
X_4055_ _4055_/D _4192_/CLK _4055_/Q vdd gnd DFFPOSX1
XFILL_0__3777_ vdd gnd FILL
X_4124_ _4124_/D _4157_/CLK _4124_/Q vdd gnd DFFPOSX1
X_3908_ _3908_/D _3908_/CLK _3908_/Q vdd gnd DFFPOSX1
X_3839_ _3839_/D _4054_/CLK _3839_/Q vdd gnd DFFPOSX1
XFILL_1__2004_ vdd gnd FILL
XFILL_1__2837_ vdd gnd FILL
XFILL_0__3700_ vdd gnd FILL
XFILL_0__2513_ vdd gnd FILL
XFILL_0__3493_ vdd gnd FILL
XFILL_0__3631_ vdd gnd FILL
X_2170_ _3735_/B _2170_/B _2173_/B vdd gnd NOR2X1
X_1954_ _4078_/Q _3712_/B vdd gnd INVX1
X_3555_ _3603_/A _3555_/B _3555_/C _4021_/D vdd gnd AOI21X1
X_3624_ _3624_/A _3625_/A _3626_/D vdd gnd OR2X2
X_2506_ _3809_/A _2592_/B _2506_/C _2507_/A vdd gnd OAI21X1
X_2368_ _2375_/C _2368_/B _3871_/Q _2370_/B vdd gnd OAI21X1
X_2437_ _2446_/B _2445_/C vdd gnd INVX1
X_3486_ _3626_/B _3522_/B vdd gnd INVX2
XFILL_1__2484_ vdd gnd FILL
X_2299_ _3478_/C _3479_/B _3691_/C vdd gnd NAND2X1
X_4038_ _4038_/D _4049_/CLK _4038_/Q vdd gnd DFFPOSX1
X_4107_ _4107_/D _4148_/CLK _4107_/Q vdd gnd DFFPOSX1
XFILL_1__3105_ vdd gnd FILL
XFILL_1__3869_ vdd gnd FILL
XFILL_0_CLKBUF1_insert171 vdd gnd FILL
XFILL_0_CLKBUF1_insert160 vdd gnd FILL
XFILL_0__2091_ vdd gnd FILL
XFILL_0__2993_ vdd gnd FILL
X_3271_ _4160_/Q _3273_/A vdd gnd INVX1
X_3340_ _3968_/Q _3748_/A vdd gnd INVX1
X_2222_ _2655_/A _2222_/B _4103_/D vdd gnd NOR2X1
X_2084_ _4086_/Q _3923_/Q _2120_/S _2085_/B vdd gnd MUX2X1
XFILL_0__3545_ vdd gnd FILL
X_2153_ _2153_/A _4034_/Q _2154_/A vdd gnd NAND2X1
XFILL_0__3614_ vdd gnd FILL
X_2986_ _3900_/Q _3898_/Q _2986_/S _2988_/B vdd gnd MUX2X1
XFILL_0__2427_ vdd gnd FILL
XFILL_0__2289_ vdd gnd FILL
X_1937_ _1939_/A _1937_/B _3770_/Y _4165_/D vdd gnd AOI21X1
X_3607_ _3607_/A _3607_/B _3607_/C _3990_/D vdd gnd AOI21X1
X_3538_ _4029_/Q _3603_/A _3539_/C vdd gnd NOR2X1
XFILL_1__3585_ vdd gnd FILL
X_3469_ _3704_/B _3469_/B _3469_/C _3924_/D vdd gnd OAI21X1
XFILL_1__2467_ vdd gnd FILL
XFILL_0__3330_ vdd gnd FILL
XFILL131850x118950 vdd gnd FILL
X_2840_ _2843_/B _2840_/B _2840_/C _2841_/A vdd gnd OAI21X1
XFILL_0__3261_ vdd gnd FILL
X_2771_ _2771_/A _2771_/B _2950_/S _2773_/B vdd gnd OAI21X1
XFILL_0__2143_ vdd gnd FILL
XFILL_0__2976_ vdd gnd FILL
X_3323_ _4145_/Q _3325_/B _3323_/C _3324_/D vdd gnd OAI21X1
X_3254_ _4173_/Q _3272_/B _3391_/S _3255_/D vdd gnd OAI21X1
X_2205_ _4107_/Q _3731_/B vdd gnd INVX1
X_3185_ _3245_/B _3186_/A _3187_/B vdd gnd OR2X2
XFILL_0__1927_ vdd gnd FILL
XFILL_1__2321_ vdd gnd FILL
XFILL_0__3459_ vdd gnd FILL
X_2136_ _2136_/A _2154_/B _2137_/A vdd gnd NOR2X1
X_2067_ _2227_/C _2067_/B _2067_/C _2068_/A vdd gnd OAI21X1
XFILL_0__3528_ vdd gnd FILL
X_2969_ _2969_/A _2997_/B _3912_/D vdd gnd AND2X2
XFILL_0__2830_ vdd gnd FILL
X_3941_ _3941_/D _4100_/CLK _3941_/Q vdd gnd DFFPOSX1
X_2823_ _3985_/Q _2827_/B _2824_/C vdd gnd NAND2X1
X_3872_ _3872_/D _4139_/CLK _3872_/Q vdd gnd DFFPOSX1
X_2754_ _2754_/A _4020_/D vdd gnd INVX1
XFILL_0__3244_ vdd gnd FILL
XFILL_0__2126_ vdd gnd FILL
XFILL_0__2057_ vdd gnd FILL
X_2685_ _4037_/Q _2685_/B _2685_/S _2686_/B vdd gnd MUX2X1
X_3306_ _3832_/Q _3732_/A vdd gnd INVX1
X_3168_ _3850_/Q _3168_/B _3175_/C _3169_/C vdd gnd OAI21X1
X_3237_ _3237_/A _3245_/B _3264_/C _4178_/D vdd gnd OAI21X1
X_2119_ _2119_/A _2119_/B _2155_/C _2121_/C vdd gnd OAI21X1
XFILL_1__3422_ vdd gnd FILL
XFILL_1__2304_ vdd gnd FILL
X_3099_ _3739_/A _3739_/B _3390_/S _3100_/A vdd gnd MUX2X1
XFILL_1__2097_ vdd gnd FILL
XFILL131550x28950 vdd gnd FILL
X_2470_ _2470_/A _2470_/B _2685_/S _2479_/A vdd gnd NAND3X1
XFILL_0__2813_ vdd gnd FILL
X_4140_ _4140_/D _4157_/CLK _4140_/Q vdd gnd DFFPOSX1
XFILL_0__2744_ vdd gnd FILL
X_3022_ _3022_/A _3022_/B _3022_/C _3023_/A vdd gnd OAI21X1
XFILL_1_BUFX2_insert17 vdd gnd FILL
XFILL_1_BUFX2_insert39 vdd gnd FILL
X_4071_ _4071_/D _4071_/CLK _4071_/Q vdd gnd DFFPOSX1
X_3924_ _3924_/D _4196_/CLK _3924_/Q vdd gnd DFFPOSX1
X_2737_ _2737_/A _2737_/B _2748_/C vdd gnd AND2X2
X_2806_ _3991_/Q _3989_/Q _2895_/A _2808_/B vdd gnd MUX2X1
X_2668_ _3807_/B _2668_/B _2669_/A vdd gnd NAND2X1
X_3855_ _3855_/D _4135_/CLK _3855_/Q vdd gnd DFFPOSX1
XFILL_0__3158_ vdd gnd FILL
X_3786_ _3787_/A _3787_/B _3806_/Y _3789_/B vdd gnd OAI21X1
X_2599_ _4064_/Q _2607_/B _2758_/A _2600_/C vdd gnd OAI21X1
XFILL_1__2784_ vdd gnd FILL
XFILL_1__3405_ vdd gnd FILL
XBUFX2_insert31 i_rst_n _3009_/B vdd gnd BUFX2
XBUFX2_insert20 _4016_/Q _2546_/B vdd gnd BUFX2
XBUFX2_insert42 _2905_/Y _2988_/A vdd gnd BUFX2
XFILL_1__3198_ vdd gnd FILL
XBUFX2_insert86 _4032_/Q _3006_/S vdd gnd BUFX2
XBUFX2_insert97 _3860_/Y _3141_/C vdd gnd BUFX2
XBUFX2_insert53 _3856_/Q _3350_/B vdd gnd BUFX2
XBUFX2_insert75 _4176_/Q _3597_/A vdd gnd BUFX2
XFILL_0__2460_ vdd gnd FILL
X_1970_ _3771_/A _1970_/B _4161_/D vdd gnd NOR2X1
X_2522_ _4062_/Q _2522_/B _2522_/C _2523_/C vdd gnd NAND3X1
X_3640_ _3642_/C _3672_/B _3640_/C _3672_/D _3957_/D vdd gnd OAI22X1
X_3571_ _3622_/A _3571_/B _3571_/C _4008_/D vdd gnd AOI21X1
X_4123_ _4123_/D _4173_/CLK _4123_/Q vdd gnd DFFPOSX1
X_2384_ _2403_/A _2392_/B vdd gnd INVX1
X_2453_ _3871_/Q _4154_/Q _2458_/B vdd gnd NOR2X1
XFILL_0__3776_ vdd gnd FILL
XFILL_0__2727_ vdd gnd FILL
X_4054_ _4054_/D _4054_/CLK _4054_/Q vdd gnd DFFPOSX1
X_3005_ _3005_/A _3976_/R _3894_/D vdd gnd AND2X2
XFILL_0__2658_ vdd gnd FILL
XFILL_1__3052_ vdd gnd FILL
X_3838_ _4180_/R vdd _3838_/D _4193_/CLK _3838_/Q vdd gnd DFFSR
X_3907_ _3907_/D _4119_/CLK _3907_/Q vdd gnd DFFPOSX1
X_3769_ _3926_/Y _3811_/Y _3805_/Y _3769_/Y vdd gnd OAI21X1
XFILL_0__1960_ vdd gnd FILL
XFILL_0__3561_ vdd gnd FILL
XFILL_0__2443_ vdd gnd FILL
XFILL_0__2374_ vdd gnd FILL
X_1953_ _3846_/Q _1958_/C _1956_/A vdd gnd NOR2X1
X_2505_ _2608_/A _2608_/B _4095_/Q _2506_/C vdd gnd OAI21X1
X_3554_ _4021_/Q _3603_/A _3555_/C vdd gnd NOR2X1
X_3485_ _3485_/A _3485_/B _3626_/B _4051_/D vdd gnd MUX2X1
X_3623_ _3980_/Q _3626_/A vdd gnd INVX1
XFILL_1__2621_ vdd gnd FILL
X_2367_ _3238_/A _2377_/A _2367_/C _2368_/B vdd gnd OAI21X1
XFILL_0__3759_ vdd gnd FILL
X_2436_ _3183_/A _4192_/Q _2436_/C _2446_/B vdd gnd AOI21X1
X_4106_ _4106_/D _4106_/CLK _4106_/Q vdd gnd DFFPOSX1
X_2298_ _3466_/C _3479_/B vdd gnd INVX1
X_4037_ _4037_/D _4189_/CLK _4037_/Q vdd gnd DFFPOSX1
XFILL_1__3035_ vdd gnd FILL
XFILL_1__2819_ vdd gnd FILL
XFILL_0__2090_ vdd gnd FILL
X_3270_ _3270_/A _3370_/B _3270_/C _3270_/D _4162_/D vdd gnd AOI22X1
X_2152_ _3737_/B _2152_/B _2155_/B vdd gnd NOR2X1
XFILL_0__1943_ vdd gnd FILL
X_2221_ _2221_/A _4103_/Q _2654_/S _2222_/B vdd gnd MUX2X1
X_2083_ _2083_/A _2083_/B _2182_/C _2085_/C vdd gnd OAI21X1
XFILL_0__3475_ vdd gnd FILL
X_2985_ _2985_/A _2997_/B _3904_/D vdd gnd AND2X2
XFILL_0__2357_ vdd gnd FILL
XFILL_0__2288_ vdd gnd FILL
X_1936_ _1948_/A _3764_/Y _4165_/Q _1937_/B vdd gnd OAI21X1
X_3606_ _3990_/Q _3607_/A _3607_/C vdd gnd NOR2X1
X_3537_ _3593_/A _4034_/Q _3537_/C _3539_/B vdd gnd OAI21X1
XFILL_1__3722_ vdd gnd FILL
X_3468_ _3468_/A _3473_/C _3469_/B _3469_/C vdd gnd OAI21X1
XFILL_0_BUFX2_insert41 vdd gnd FILL
X_2419_ _2421_/A _2421_/B _2420_/B vdd gnd NOR2X1
XFILL_0_BUFX2_insert30 vdd gnd FILL
XFILL132750x57750 vdd gnd FILL
XFILL_0_BUFX2_insert52 vdd gnd FILL
XFILL_0_BUFX2_insert74 vdd gnd FILL
X_3399_ _4114_/Q _3402_/B vdd gnd INVX1
XFILL_0_BUFX2_insert85 vdd gnd FILL
XFILL_0_BUFX2_insert96 vdd gnd FILL
X_2770_ _4011_/Q _2774_/B _2773_/A vdd gnd NAND2X1
XFILL_0__3191_ vdd gnd FILL
XFILL_0__2073_ vdd gnd FILL
XFILL_0__2211_ vdd gnd FILL
XFILL_0__2975_ vdd gnd FILL
X_3322_ _4143_/Q _3324_/A vdd gnd INVX1
X_3253_ _4172_/Q _3255_/A vdd gnd INVX1
X_3184_ _3184_/A _3184_/B _3926_/A _4196_/D vdd gnd AOI21X1
X_2135_ _2153_/A _4027_/Q _2136_/A vdd gnd NAND2X1
X_2204_ _2655_/A _2204_/B _4107_/D vdd gnd NOR2X1
XFILL_1__2251_ vdd gnd FILL
XFILL_0__3389_ vdd gnd FILL
X_2066_ _4082_/Q _3915_/Q _2228_/S _2067_/B vdd gnd MUX2X1
X_2899_ _2899_/A _2903_/A _3009_/B _2900_/C vdd gnd OAI21X1
X_2968_ _2972_/A _2968_/B _2968_/C _2969_/A vdd gnd OAI21X1
X_1919_ _4171_/Q _3715_/B vdd gnd INVX2
XFILL132750x32550 vdd gnd FILL
XFILL_1__2449_ vdd gnd FILL
XFILL_1__3567_ vdd gnd FILL
XFILL_0__2760_ vdd gnd FILL
XFILL_0__2691_ vdd gnd FILL
X_3940_ _3940_/D _4003_/CLK _3940_/Q vdd gnd DFFPOSX1
XFILL_0__3312_ vdd gnd FILL
X_3871_ _3871_/D _3806_/A _3871_/Q vdd gnd DFFPOSX1
X_2822_ _3983_/Q _3981_/Q _2994_/S _2824_/B vdd gnd MUX2X1
X_2753_ _4015_/Q _3358_/C _3080_/C _2754_/A vdd gnd NAND3X1
X_2684_ _2684_/A _2684_/B _4039_/D vdd gnd NOR2X1
XFILL_0__3174_ vdd gnd FILL
XFILL_0__2125_ vdd gnd FILL
XFILL_0__2958_ vdd gnd FILL
X_3305_ _3385_/B _3305_/B _3305_/C _4151_/D vdd gnd AOI21X1
XFILL_0__2889_ vdd gnd FILL
XFILL_1__3352_ vdd gnd FILL
X_3098_ _4197_/Q _3739_/A vdd gnd INVX1
X_3167_ _4178_/Q _4193_/Q _3175_/C vdd gnd NOR2X1
X_3236_ _3382_/B _3794_/D _3264_/C vdd gnd OR2X2
X_2118_ _2118_/A _2154_/B _2119_/A vdd gnd NOR2X1
X_2049_ _2645_/A _2049_/B _2049_/C _2050_/A vdd gnd OAI21X1
XFILL132450x79350 vdd gnd FILL
XFILL_0__2812_ vdd gnd FILL
XFILL_0__3792_ vdd gnd FILL
X_4070_ _4070_/D _4089_/CLK _4070_/Q vdd gnd DFFPOSX1
X_3021_ _3021_/A _3021_/B _3038_/C _3888_/D vdd gnd AOI21X1
XFILL_0__2674_ vdd gnd FILL
X_2805_ _2805_/A _3009_/B _3995_/D vdd gnd AND2X2
X_3854_ _3854_/D _4040_/CLK _3854_/Q vdd gnd DFFPOSX1
X_3923_ _3923_/D _4094_/CLK _3923_/Q vdd gnd DFFPOSX1
XFILL_0__3226_ vdd gnd FILL
X_2736_ _2736_/A _2736_/B _2737_/B vdd gnd AND2X2
X_2667_ _3081_/A _3081_/B _2668_/B vdd gnd NOR2X1
XFILL_0__3088_ vdd gnd FILL
XFILL_0_BUFX2_insert181 vdd gnd FILL
XFILL_0__2108_ vdd gnd FILL
X_3785_ _3852_/Q _3787_/A vdd gnd INVX1
X_2598_ _2598_/A _2607_/B _2598_/C _4066_/D vdd gnd AOI21X1
X_3219_ _3773_/Y _3219_/B _3771_/A _4185_/D vdd gnd AOI21X1
XFILL132450x54150 vdd gnd FILL
X_4199_ _4199_/D _4199_/CLK _4199_/Q vdd gnd DFFPOSX1
XBUFX2_insert21 i_rst_n _3901_/A vdd gnd BUFX2
XBUFX2_insert43 _2905_/Y _2960_/A vdd gnd BUFX2
XBUFX2_insert54 _3856_/Q _3798_/A vdd gnd BUFX2
XBUFX2_insert32 _1956_/Y _2172_/B vdd gnd BUFX2
XBUFX2_insert10 _2390_/Y _3453_/S vdd gnd BUFX2
XFILL_1__2079_ vdd gnd FILL
XBUFX2_insert87 _4032_/Q _2986_/S vdd gnd BUFX2
XBUFX2_insert98 _3860_/Y _3926_/A vdd gnd BUFX2
XBUFX2_insert76 _4176_/Q _3609_/A vdd gnd BUFX2
XFILL_0__3011_ vdd gnd FILL
XFILL_0__2390_ vdd gnd FILL
X_2521_ _2521_/A _2685_/S _2522_/C vdd gnd NAND2X1
X_3570_ _4008_/Q _3622_/A _3571_/C vdd gnd NOR2X1
X_2383_ _2424_/B _2383_/B _2463_/A _2403_/A vdd gnd AOI21X1
X_2452_ _3681_/A _2452_/B _3690_/A vdd gnd NOR2X1
X_4122_ _4122_/D _4146_/CLK _4122_/Q vdd gnd DFFPOSX1
X_4053_ _4053_/D _4200_/CLK _4053_/Q vdd gnd DFFPOSX1
XFILL_0__2588_ vdd gnd FILL
X_3004_ _3008_/A _3004_/B _3004_/C _3005_/A vdd gnd OAI21X1
X_3837_ _3837_/D _4054_/CLK _3837_/Q vdd gnd DFFPOSX1
X_3906_ _3906_/D _3908_/CLK _3906_/Q vdd gnd DFFPOSX1
XFILL_0__3209_ vdd gnd FILL
X_3768_ _3769_/Y _3803_/Y _3768_/Y vdd gnd AND2X2
X_2719_ _3845_/Q _3847_/Q _2721_/A vdd gnd NOR2X1
X_3699_ _3699_/A _3699_/B _3714_/B vdd gnd NOR2X1
XFILL_1__2766_ vdd gnd FILL
XFILL_0__2511_ vdd gnd FILL
XFILL_0__3491_ vdd gnd FILL
XFILL_0__2442_ vdd gnd FILL
X_3622_ _3622_/A _3622_/B _3622_/C _3982_/D vdd gnd AOI21X1
X_1952_ _3984_/Q _3618_/B vdd gnd INVX1
X_2504_ _2607_/B _2592_/B vdd gnd INVX2
X_2435_ _3818_/Q _4200_/Q _3708_/A _2436_/C vdd gnd OAI21X1
X_3553_ _3605_/A _4023_/Q _3553_/C _3555_/B vdd gnd OAI21X1
X_3484_ _3625_/A _3980_/Q _3484_/C _3485_/B vdd gnd OAI21X1
XFILL_0__2709_ vdd gnd FILL
XFILL_0__3689_ vdd gnd FILL
X_2366_ _4188_/Q _4189_/Q _3276_/A _2367_/C vdd gnd AOI21X1
X_2297_ _3913_/Y _3478_/C vdd gnd INVX2
X_4036_ _4036_/D _4036_/CLK _4036_/Q vdd gnd DFFPOSX1
X_4105_ _4105_/D _4148_/CLK _4105_/Q vdd gnd DFFPOSX1
XFILL_1__2749_ vdd gnd FILL
XFILL_0_CLKBUF1_insert151 vdd gnd FILL
XFILL_0_CLKBUF1_insert162 vdd gnd FILL
XFILL_0_CLKBUF1_insert140 vdd gnd FILL
XFILL_0__2991_ vdd gnd FILL
XFILL_0__3543_ vdd gnd FILL
X_2151_ _4120_/Q _3737_/B vdd gnd INVX1
X_2082_ _2082_/A _2181_/B _2083_/A vdd gnd NOR2X1
X_2220_ _2227_/C _2220_/B _2220_/C _2221_/A vdd gnd OAI21X1
XFILL_0__3612_ vdd gnd FILL
X_2984_ _2992_/A _2984_/B _2984_/C _2985_/A vdd gnd OAI21X1
XFILL_0__2425_ vdd gnd FILL
X_3605_ _3605_/A _3992_/Q _3605_/C _3607_/B vdd gnd OAI21X1
X_1935_ _1945_/A _1941_/B _1939_/A vdd gnd NAND2X1
X_2418_ _2418_/A _2421_/B vdd gnd INVX1
X_3467_ _3470_/B _3470_/A _3467_/C _3473_/C vdd gnd AOI21X1
X_3536_ _3593_/A _3737_/B _3537_/C vdd gnd NAND2X1
X_3398_ _3400_/B _3398_/B _3448_/S _4117_/D vdd gnd MUX2X1
XFILL_1__1982_ vdd gnd FILL
X_4019_ _4019_/D _4019_/CLK _4019_/Q vdd gnd DFFPOSX1
XFILL_1__2603_ vdd gnd FILL
X_2349_ _3802_/A _2349_/B _2681_/A vdd gnd NAND2X1
XFILL_1__3017_ vdd gnd FILL
XFILL_1__2396_ vdd gnd FILL
XFILL132450x3750 vdd gnd FILL
XFILL_0__2141_ vdd gnd FILL
XFILL132750x118950 vdd gnd FILL
X_3321_ _3321_/A _3388_/A _3321_/C _3321_/D _4145_/D vdd gnd AOI22X1
X_3252_ _3252_/A _3370_/B _3252_/C _3252_/D _4173_/D vdd gnd AOI22X1
XFILL_0__1925_ vdd gnd FILL
X_3183_ _3183_/A _3183_/B _4196_/Q _3184_/B vdd gnd OAI21X1
XFILL_0__3526_ vdd gnd FILL
X_2134_ _3739_/B _2152_/B _2137_/B vdd gnd NOR2X1
X_2065_ _2065_/A _2065_/B _2157_/A _2067_/C vdd gnd OAI21X1
X_2203_ _2203_/A _4107_/Q _2654_/S _2204_/B vdd gnd MUX2X1
XFILL_0__2339_ vdd gnd FILL
X_2967_ _3912_/Q _2972_/A _2968_/C vdd gnd NAND2X1
XFILL_0__3457_ vdd gnd FILL
XFILL_0__2408_ vdd gnd FILL
XFILL_1__2181_ vdd gnd FILL
X_2898_ _2898_/A _3022_/B _2898_/C _2899_/A vdd gnd OAI21X1
X_1918_ _4078_/Q _3764_/Y _4171_/Q _1921_/B vdd gnd OAI21X1
X_3519_ _3519_/A _3525_/B _3526_/S _3520_/C vdd gnd OAI21X1
XFILL_1__1965_ vdd gnd FILL
XFILL_1__3704_ vdd gnd FILL
XFILL_1__3497_ vdd gnd FILL
XFILL_1__2379_ vdd gnd FILL
X_2821_ _2821_/A _2885_/B _3987_/D vdd gnd AND2X2
XFILL_0_BUFX2_insert1 vdd gnd FILL
X_3870_ _3870_/D _4139_/CLK _3870_/Q vdd gnd DFFPOSX1
XFILL_0__3242_ vdd gnd FILL
XFILL_0__3173_ vdd gnd FILL
X_2752_ _2752_/A _2752_/B _3038_/C _4022_/D vdd gnd AOI21X1
X_2683_ _3080_/C _2683_/B _2684_/B vdd gnd NAND2X1
XFILL_0__2055_ vdd gnd FILL
X_3304_ _4151_/Q _3385_/B _3305_/C vdd gnd NOR2X1
X_3235_ _4132_/Q _3235_/B _3235_/C _3794_/D vdd gnd OAI21X1
X_3097_ _3843_/Q _3323_/C _3101_/B vdd gnd NAND2X1
X_3166_ _4198_/Q _3182_/A vdd gnd INVX1
X_2117_ _2153_/A _4023_/Q _2118_/A vdd gnd NAND2X1
X_2048_ _4077_/Q _3907_/Q _2228_/S _2049_/B vdd gnd MUX2X1
XFILL_1__2233_ vdd gnd FILL
X_3999_ _3999_/D _4052_/CLK _3999_/Q vdd gnd DFFPOSX1
XFILL_0__2742_ vdd gnd FILL
X_3020_ _3888_/Q _3027_/A _3021_/A vdd gnd NAND2X1
X_3922_ _3922_/D _4030_/CLK _3922_/Q vdd gnd DFFPOSX1
X_2804_ _2903_/A _2804_/B _2804_/C _2805_/A vdd gnd OAI21X1
X_3853_ _3853_/D _4135_/CLK _3853_/Q vdd gnd DFFPOSX1
XFILL_0__3156_ vdd gnd FILL
X_3784_ _3885_/Q _3885_/D vdd gnd INVX1
X_2735_ _3025_/S _2735_/B _2736_/B vdd gnd NOR2X1
X_2597_ _4066_/Q _2607_/B _2758_/A _2598_/C vdd gnd OAI21X1
X_2666_ _3081_/A _3081_/B _4042_/Q _2669_/B vdd gnd OAI21X1
XFILL_1__2920_ vdd gnd FILL
XFILL_0_BUFX2_insert182 vdd gnd FILL
XFILL_0__2038_ vdd gnd FILL
X_3149_ _3901_/A _3921_/B _3821_/D vdd gnd AND2X2
X_4198_ _4198_/D _4200_/CLK _4198_/Q vdd gnd DFFPOSX1
X_3218_ _4048_/Q _3218_/B _4185_/Q _3219_/B vdd gnd OAI21X1
XFILL_1__3334_ vdd gnd FILL
XFILL_1__2216_ vdd gnd FILL
XBUFX2_insert22 i_rst_n _2885_/B vdd gnd BUFX2
XBUFX2_insert88 _4032_/Q _2895_/A vdd gnd BUFX2
XBUFX2_insert77 _2622_/Y _3351_/B vdd gnd BUFX2
XBUFX2_insert55 _3856_/Q _3390_/S vdd gnd BUFX2
XBUFX2_insert33 _1956_/Y _2650_/B vdd gnd BUFX2
XBUFX2_insert99 _1951_/Y _2654_/S vdd gnd BUFX2
XBUFX2_insert11 _2390_/Y _3475_/A vdd gnd BUFX2
XBUFX2_insert44 _3481_/Y _3622_/A vdd gnd BUFX2
XFILL_0__3010_ vdd gnd FILL
X_2520_ _3870_/Q _2543_/B _2522_/B vdd gnd NAND2X1
X_2451_ _4154_/Q _2452_/B vdd gnd INVX1
X_4052_ _4052_/D _4052_/CLK _4052_/Q vdd gnd DFFPOSX1
XFILL_0__2725_ vdd gnd FILL
X_3003_ _3894_/Q _3008_/A _3004_/C vdd gnd NAND2X1
X_2382_ _3157_/A _3159_/B _3183_/A _2383_/B vdd gnd OAI21X1
XFILL_0__3774_ vdd gnd FILL
X_4121_ _4121_/D _3214_/A _4121_/Q vdd gnd DFFPOSX1
XFILL_0__2656_ vdd gnd FILL
X_3905_ _4190_/Q _3905_/Y vdd gnd INVX2
X_2718_ _3843_/Q _3103_/C _2726_/B vdd gnd NOR2X1
X_3836_ _4180_/R vdd _3836_/D _4166_/CLK _3836_/Q vdd gnd DFFSR
XFILL_0__3208_ vdd gnd FILL
X_3767_ _4048_/Q _3767_/Y vdd gnd INVX1
XFILL_1__2903_ vdd gnd FILL
X_3698_ _3698_/A _3698_/B _3698_/C _3699_/A vdd gnd OAI21X1
X_2649_ _2649_/A _3980_/Q _2650_/A vdd gnd NAND2X1
XFILL_1__2696_ vdd gnd FILL
XFILL_1__3317_ vdd gnd FILL
XFILL_0__2372_ vdd gnd FILL
XFILL_0__3490_ vdd gnd FILL
XFILL132450x129750 vdd gnd FILL
X_3552_ _3593_/A _3741_/B _3553_/C vdd gnd NAND2X1
X_1951_ _1951_/A _3764_/Y _3773_/Y _1951_/Y vdd gnd OAI21X1
X_3621_ _3982_/Q _3622_/A _3622_/C vdd gnd NOR2X1
X_2503_ _2608_/A _2608_/B _2607_/B vdd gnd NOR2X1
X_2365_ _4179_/Q _4191_/Q _3276_/A vdd gnd NOR2X1
X_2434_ _2434_/A _2434_/B _2434_/C _2462_/A vdd gnd NAND3X1
X_3483_ _3625_/A _3727_/B _3484_/C vdd gnd NAND2X1
XFILL_1__2550_ vdd gnd FILL
X_2296_ _3864_/Q _3724_/B vdd gnd INVX1
X_4035_ _4035_/D _4040_/CLK _4035_/Q vdd gnd DFFPOSX1
XFILL_0__3757_ vdd gnd FILL
X_4104_ _4104_/D _4106_/CLK _4104_/Q vdd gnd DFFPOSX1
XFILL_0__3688_ vdd gnd FILL
X_3819_ _3819_/D _4040_/CLK _3921_/A vdd gnd DFFPOSX1
XFILL_0__1941_ vdd gnd FILL
X_2150_ _2186_/A _2150_/B _4120_/D vdd gnd NOR2X1
X_2081_ _2180_/A _4010_/Q _2082_/A vdd gnd NAND2X1
XFILL_0__3473_ vdd gnd FILL
X_2983_ _3904_/Q _2992_/A _2984_/C vdd gnd NAND2X1
XFILL_0__2355_ vdd gnd FILL
XFILL_0__2286_ vdd gnd FILL
X_1934_ _1948_/A _3764_/Y _1941_/B vdd gnd NOR2X1
X_3604_ _3605_/A _3755_/B _3605_/C vdd gnd NAND2X1
X_3535_ _3603_/A _3535_/B _3535_/C _4034_/D vdd gnd AOI21X1
X_2417_ _3692_/B _2424_/C _2417_/C _2418_/A vdd gnd NAND3X1
X_2348_ _2462_/B _2422_/A _2412_/B _2349_/B vdd gnd NAND3X1
X_3466_ _3470_/A _3470_/B _3466_/C _3467_/C vdd gnd OAI21X1
XFILL_1__3651_ vdd gnd FILL
X_3397_ _4117_/Q _3400_/B vdd gnd INVX1
XFILL_1__2533_ vdd gnd FILL
XFILL_0_BUFX2_insert21 vdd gnd FILL
XFILL_0_BUFX2_insert87 vdd gnd FILL
XFILL_0_BUFX2_insert43 vdd gnd FILL
XFILL_0_BUFX2_insert98 vdd gnd FILL
XFILL_0_BUFX2_insert54 vdd gnd FILL
X_2279_ _4047_/Q _3493_/B _3496_/B _2283_/A vdd gnd OAI21X1
XFILL_0_BUFX2_insert76 vdd gnd FILL
X_4018_ _4018_/D _4027_/CLK _4018_/Q vdd gnd DFFPOSX1
XFILL_0_BUFX2_insert32 vdd gnd FILL
XFILL_0_BUFX2_insert10 vdd gnd FILL
XFILL_0__2071_ vdd gnd FILL
X_3320_ _4147_/Q _3325_/B _3323_/C _3321_/D vdd gnd OAI21X1
XFILL_0__2973_ vdd gnd FILL
X_3251_ _3364_/A _3272_/B _3370_/B vdd gnd AND2X2
X_3182_ _3182_/A _3186_/A _3182_/C _4198_/D vdd gnd OAI21X1
X_2202_ _2653_/A _2202_/B _2202_/C _2203_/A vdd gnd OAI21X1
XFILL_0__3525_ vdd gnd FILL
X_2064_ _2064_/A _2181_/B _2065_/A vdd gnd NOR2X1
X_2133_ _4124_/Q _3739_/B vdd gnd INVX1
X_2897_ _2897_/A _2897_/B _3038_/C _3950_/D vdd gnd AOI21X1
X_2966_ _3910_/Q _3908_/Q _2986_/S _2968_/B vdd gnd MUX2X1
XFILL_0__3387_ vdd gnd FILL
XFILL_0__2407_ vdd gnd FILL
XFILL_0__2269_ vdd gnd FILL
X_1917_ _3719_/Y o_mem_mosi vdd gnd BUFX2
X_3518_ _3518_/A _3518_/B _3520_/B vdd gnd NOR2X1
X_3449_ _3921_/A _3921_/B _3449_/C _3450_/B vdd gnd OAI21X1
XFILL_1__3634_ vdd gnd FILL
XFILL132450x82950 vdd gnd FILL
XFILL_0__3310_ vdd gnd FILL
X_2751_ _4024_/Q _3025_/S _2751_/C _2751_/D _2752_/B vdd gnd AOI22X1
X_2820_ _2827_/B _2820_/B _2820_/C _2821_/A vdd gnd OAI21X1
XFILL_0__2123_ vdd gnd FILL
X_2682_ _2764_/C _2682_/B _2682_/C _2683_/B vdd gnd OAI21X1
XFILL_0__2887_ vdd gnd FILL
XFILL_0__2956_ vdd gnd FILL
X_3303_ _4153_/Q _3310_/B _3303_/C _3305_/B vdd gnd OAI21X1
X_3165_ _3901_/A _3917_/A _4199_/D vdd gnd AND2X2
X_3234_ _3235_/B _3743_/A _3235_/C vdd gnd NAND2X1
X_3096_ _3255_/C _3096_/B _3141_/C _3845_/D vdd gnd AOI21X1
XFILL_1__3281_ vdd gnd FILL
X_2116_ _3741_/B _2152_/B _2119_/B vdd gnd NOR2X1
XFILL_0__3508_ vdd gnd FILL
X_2047_ _2047_/A _2047_/B _2645_/A _2049_/C vdd gnd OAI21X1
X_2949_ _2949_/A _4197_/R _3922_/D vdd gnd AND2X2
X_3998_ _3998_/D _4049_/CLK _3998_/Q vdd gnd DFFPOSX1
XFILL_1__2163_ vdd gnd FILL
XFILL_1__1947_ vdd gnd FILL
XFILL_1__3479_ vdd gnd FILL
XFILL_0__2810_ vdd gnd FILL
XFILL_0__3790_ vdd gnd FILL
XFILL_0__2672_ vdd gnd FILL
X_3921_ _3921_/A _3921_/B _3921_/Y vdd gnd NOR2X1
X_2734_ _2734_/A _2734_/B _2747_/C _4028_/D vdd gnd AOI21X1
X_2803_ _3995_/Q _2903_/A _2804_/C vdd gnd NAND2X1
XFILL_0__3086_ vdd gnd FILL
X_3783_ _3783_/A _3783_/B _3889_/D vdd gnd NOR2X1
XFILL_0__2106_ vdd gnd FILL
XFILL_0__3224_ vdd gnd FILL
X_3852_ _3852_/D _4101_/CLK _3852_/Q vdd gnd DFFPOSX1
X_2596_ _2596_/A _2596_/B _3071_/C _4068_/D vdd gnd AOI21X1
XFILL_1__2850_ vdd gnd FILL
X_2665_ _3853_/Q _3078_/B _3081_/B vdd gnd NAND2X1
XFILL_0__2037_ vdd gnd FILL
X_4197_ _4197_/R vdd _4197_/D _4197_/CLK _4197_/Q vdd gnd DFFSR
X_3217_ _3217_/A _3947_/S _4187_/D vdd gnd AND2X2
X_3148_ _3685_/C _3688_/B _3148_/C _3148_/D _3823_/D vdd gnd OAI22X1
X_3079_ _3079_/A _3853_/D vdd gnd INVX1
XFILL_1__3264_ vdd gnd FILL
XBUFX2_insert23 i_rst_n _3976_/R vdd gnd BUFX2
XBUFX2_insert89 _4032_/Q _2950_/S vdd gnd BUFX2
XBUFX2_insert78 _2622_/Y _3369_/A vdd gnd BUFX2
XBUFX2_insert56 _3856_/Q _3286_/A vdd gnd BUFX2
XBUFX2_insert45 _3481_/Y _3607_/A vdd gnd BUFX2
XBUFX2_insert34 _1956_/Y _2181_/B vdd gnd BUFX2
XBUFX2_insert12 _4187_/Q _3718_/A vdd gnd BUFX2
X_2381_ _3817_/Q _3159_/B vdd gnd INVX1
X_2450_ _3871_/Q _3681_/A vdd gnd INVX1
XFILL_0__2724_ vdd gnd FILL
X_3002_ _3892_/Q _3890_/Q _3006_/S _3004_/B vdd gnd MUX2X1
X_4120_ _4120_/D _4146_/CLK _4120_/Q vdd gnd DFFPOSX1
X_4051_ _4051_/D _4196_/CLK _4051_/Q vdd gnd DFFPOSX1
XFILL_0__2586_ vdd gnd FILL
X_3904_ _3904_/D _3908_/CLK _3904_/Q vdd gnd DFFPOSX1
XFILL_1__2000_ vdd gnd FILL
X_2717_ _2741_/C _2895_/B vdd gnd INVX2
X_3835_ _3835_/D _4054_/CLK _3835_/Q vdd gnd DFFPOSX1
XFILL_0__3138_ vdd gnd FILL
X_3697_ _3701_/B _3698_/C vdd gnd INVX1
X_3766_ _4202_/Q _4097_/Q _3767_/Y _3766_/Y vdd gnd OAI21X1
X_2579_ _2579_/A _2579_/B _3901_/A _2580_/A vdd gnd OAI21X1
XFILL132150x36150 vdd gnd FILL
X_2648_ _3727_/B _2648_/B _2651_/B vdd gnd NOR2X1
X_1950_ _3223_/B _3699_/B _1951_/A vdd gnd NAND2X1
XFILL_0__2440_ vdd gnd FILL
X_2502_ _2607_/A _2556_/B _4093_/Q _2608_/A vdd gnd OAI21X1
X_3551_ _3595_/A _3551_/B _3551_/C _4023_/D vdd gnd AOI21X1
X_3620_ _3620_/A _4038_/Q _3620_/C _3622_/B vdd gnd OAI21X1
X_2364_ _4179_/Q _4190_/Q _2377_/A vdd gnd NAND2X1
X_2433_ _3168_/B _2433_/B _2433_/C _4061_/Q _2434_/A vdd gnd AOI22X1
X_3482_ _3525_/B _3595_/A _3626_/B vdd gnd NOR2X1
X_4103_ _4103_/D _4148_/CLK _4103_/Q vdd gnd DFFPOSX1
XFILL_0__2638_ vdd gnd FILL
XFILL_1__2480_ vdd gnd FILL
X_2295_ _2314_/A _2314_/B _3152_/A vdd gnd NOR2X1
XFILL_0__2707_ vdd gnd FILL
X_4034_ _4034_/D _4034_/CLK _4034_/Q vdd gnd DFFPOSX1
XFILL_1__3101_ vdd gnd FILL
X_3818_ _3818_/D _4200_/CLK _3818_/Q vdd gnd DFFPOSX1
X_3749_ _3749_/A _3749_/B _3816_/S _3964_/D vdd gnd MUX2X1
XFILL_1__2678_ vdd gnd FILL
XFILL_1__3796_ vdd gnd FILL
XFILL_0_CLKBUF1_insert153 vdd gnd FILL
XFILL_0_CLKBUF1_insert131 vdd gnd FILL
XFILL_0_CLKBUF1_insert164 vdd gnd FILL
XFILL_0_CLKBUF1_insert142 vdd gnd FILL
XFILL_0_CLKBUF1_insert186 vdd gnd FILL
XFILL_0__1940_ vdd gnd FILL
XFILL_0__3610_ vdd gnd FILL
XFILL_0__2423_ vdd gnd FILL
XFILL_0__3541_ vdd gnd FILL
X_2080_ _3745_/B _2188_/B _2083_/B vdd gnd NOR2X1
X_2982_ _3902_/Q _3900_/Q _2994_/S _2984_/B vdd gnd MUX2X1
XFILL_0__2354_ vdd gnd FILL
X_1933_ _3696_/A _3698_/A _3698_/B _1948_/A vdd gnd NAND3X1
X_3465_ _3465_/A _3471_/A _3470_/A vdd gnd AND2X2
X_3603_ _3603_/A _3603_/B _3603_/C _3992_/D vdd gnd AOI21X1
X_3534_ _4034_/Q _3603_/A _3535_/C vdd gnd NOR2X1
XFILL_0__3808_ vdd gnd FILL
X_2416_ _2417_/C _2424_/C _3692_/B _2421_/A vdd gnd AOI21X1
XFILL_0__3739_ vdd gnd FILL
X_2347_ _4191_/Q _4174_/Q _2347_/C _2412_/B vdd gnd AOI21X1
X_2278_ _3519_/A _3507_/A _3508_/B _3493_/B vdd gnd NAND3X1
XFILL_1__3581_ vdd gnd FILL
X_3396_ _3398_/B _3453_/A _3453_/S _4119_/D vdd gnd MUX2X1
X_4017_ _4017_/D _4050_/CLK _4017_/Q vdd gnd DFFPOSX1
XFILL_1__3779_ vdd gnd FILL
X_3250_ _4129_/Q _3272_/B _3391_/S _3252_/D vdd gnd OAI21X1
X_3181_ _3181_/A _3181_/B _3181_/C _3182_/C vdd gnd OAI21X1
XFILL_0__1923_ vdd gnd FILL
X_2201_ _4114_/Q _3978_/Q _3221_/D _2202_/B vdd gnd MUX2X1
X_2132_ _2177_/A _2132_/B _4124_/D vdd gnd NOR2X1
X_2063_ _2180_/A _4006_/Q _2064_/A vdd gnd NAND2X1
XFILL_0__3455_ vdd gnd FILL
X_2896_ _3950_/Q _2900_/B _2897_/A vdd gnd NAND2X1
XFILL_0__2337_ vdd gnd FILL
X_2965_ _2965_/A _2997_/B _3914_/D vdd gnd AND2X2
X_1916_ _3214_/Y o_mem_sck vdd gnd BUFX2
X_3517_ _4038_/Q _3525_/A _3518_/B vdd gnd NOR2X1
X_3448_ _3456_/A _3448_/B _3448_/S _4063_/D vdd gnd MUX2X1
XFILL_1__2515_ vdd gnd FILL
X_3379_ _4179_/Q _3457_/B _3381_/B vdd gnd NAND2X1
XFILL_0_BUFX2_insert3 vdd gnd FILL
XFILL_0__3240_ vdd gnd FILL
X_2750_ _3022_/C _2751_/D vdd gnd INVX1
X_2681_ _2681_/A _2682_/B vdd gnd INVX1
XFILL_0__3171_ vdd gnd FILL
XFILL_0__2053_ vdd gnd FILL
X_3302_ _3302_/A _3310_/B _3303_/C vdd gnd NAND2X1
X_3095_ _3095_/A _3309_/B _3255_/C vdd gnd NAND2X1
X_3164_ _3183_/A _3183_/B _3186_/A _4200_/D vdd gnd AOI21X1
X_3233_ _4182_/Q _3743_/A vdd gnd INVX1
X_2115_ _4128_/Q _3741_/B vdd gnd INVX1
X_3997_ _3997_/D _3997_/CLK _3997_/Q vdd gnd DFFPOSX1
XFILL_0__3369_ vdd gnd FILL
XFILL_0__3438_ vdd gnd FILL
X_2046_ _2046_/A _2172_/B _2047_/A vdd gnd NOR2X1
X_2879_ _3956_/Q _2880_/A _2880_/C vdd gnd NAND2X1
X_2948_ _2960_/A _2948_/B _2948_/C _2949_/A vdd gnd OAI21X1
XFILL_1__2093_ vdd gnd FILL
XFILL_1__2995_ vdd gnd FILL
XFILL_1__3616_ vdd gnd FILL
XFILL_0__2740_ vdd gnd FILL
XFILL_0__2671_ vdd gnd FILL
X_3851_ _3851_/D _4135_/CLK _3851_/Q vdd gnd DFFPOSX1
X_3920_ _3920_/D _4032_/CLK _3920_/Q vdd gnd DFFPOSX1
X_2733_ _2746_/A _2895_/B _2734_/A vdd gnd NAND2X1
XFILL_0_BUFX2_insert173 vdd gnd FILL
X_2802_ _3993_/Q _3991_/Q _3019_/A _2804_/B vdd gnd MUX2X1
X_2664_ _3807_/A _3076_/B _3078_/B vdd gnd NOR2X1
XFILL_0__3085_ vdd gnd FILL
XFILL_0__3154_ vdd gnd FILL
X_3782_ _3889_/Q _3885_/Q _3783_/A vdd gnd NOR2X1
XFILL_0_BUFX2_insert184 vdd gnd FILL
X_2595_ _2608_/A _2608_/B _4068_/Q _2596_/B vdd gnd OAI21X1
XFILL_0__2938_ vdd gnd FILL
XFILL_0__2869_ vdd gnd FILL
X_3078_ _3853_/Q _3078_/B _3078_/C _3079_/A vdd gnd OAI21X1
X_4196_ _4196_/D _4196_/CLK _4196_/Q vdd gnd DFFPOSX1
X_3147_ _4198_/Q _3147_/B _3629_/A _3148_/C vdd gnd OAI21X1
X_3216_ _3710_/C _3772_/Y _3216_/C _3217_/A vdd gnd OAI21X1
XBUFX2_insert24 i_rst_n _3136_/B vdd gnd BUFX2
XBUFX2_insert13 _4187_/Q _2153_/A vdd gnd BUFX2
XFILL_1__2145_ vdd gnd FILL
X_2029_ _2029_/A _2029_/B _2182_/C _2031_/C vdd gnd OAI21X1
XBUFX2_insert79 _2622_/Y _3802_/B vdd gnd BUFX2
XBUFX2_insert46 _3481_/Y _3595_/A vdd gnd BUFX2
XBUFX2_insert35 _1956_/Y _2163_/B vdd gnd BUFX2
XBUFX2_insert57 _3143_/Y _3688_/B vdd gnd BUFX2
XFILL_1__2978_ vdd gnd FILL
X_2380_ _3818_/Q _3157_/A vdd gnd INVX1
XFILL_0__3772_ vdd gnd FILL
X_4050_ _4050_/D _4050_/CLK _4050_/Q vdd gnd DFFPOSX1
X_3001_ _3001_/A _3009_/B _3896_/D vdd gnd AND2X2
XFILL132750x7350 vdd gnd FILL
XFILL_0__2654_ vdd gnd FILL
XFILL_0__3206_ vdd gnd FILL
X_3834_ _4180_/R vdd _3834_/D _4166_/CLK _3834_/Q vdd gnd DFFSR
X_3903_ _3903_/D _4119_/CLK _3903_/Q vdd gnd DFFPOSX1
X_2716_ _4028_/Q _2741_/C _2734_/B vdd gnd NAND2X1
XFILL_0__3068_ vdd gnd FILL
X_2647_ _4099_/Q _3727_/B vdd gnd INVX1
X_3696_ _3696_/A _3696_/B _3701_/B vdd gnd NAND2X1
X_3765_ _3766_/Y _3768_/Y _4078_/Q _3765_/Y vdd gnd OAI21X1
XFILL_1__2832_ vdd gnd FILL
X_2578_ _2578_/A _4083_/D vdd gnd INVX1
XFILL_1__3246_ vdd gnd FILL
X_4179_ _4179_/D _4192_/CLK _4179_/Q vdd gnd DFFPOSX1
XFILL_1__2128_ vdd gnd FILL
XFILL_0__2370_ vdd gnd FILL
X_2501_ _2562_/C _2559_/B _2608_/B vdd gnd NAND2X1
X_3481_ _3481_/A _3481_/B _3526_/S _3481_/Y vdd gnd OAI21X1
X_3550_ _4023_/Q _3595_/A _3551_/C vdd gnd NOR2X1
X_4033_ _4033_/D _4039_/CLK _4033_/Q vdd gnd DFFPOSX1
X_2363_ _4177_/Q _3238_/A vdd gnd INVX1
X_2432_ _2432_/A _2433_/B vdd gnd INVX1
X_2294_ _2294_/A _3184_/A _3526_/S _2314_/A vdd gnd OAI21X1
XFILL_0__3755_ vdd gnd FILL
X_4102_ _4102_/D _4106_/CLK _4102_/Q vdd gnd DFFPOSX1
XFILL_0__2568_ vdd gnd FILL
XFILL_0__3686_ vdd gnd FILL
X_3748_ _3748_/A _3748_/B _3760_/S _3968_/D vdd gnd MUX2X1
X_3817_ _3817_/D _4199_/CLK _3817_/Q vdd gnd DFFPOSX1
XFILL_1__2815_ vdd gnd FILL
X_3679_ _3875_/Q _3681_/C vdd gnd INVX1
XFILL_0__3471_ vdd gnd FILL
X_2981_ _2981_/A _2997_/B _3906_/D vdd gnd AND2X2
XFILL_0__2284_ vdd gnd FILL
X_3602_ _3992_/Q _3603_/A _3603_/C vdd gnd NOR2X1
X_1932_ _4171_/Q _4078_/Q _3698_/B vdd gnd NOR2X1
X_2415_ _3200_/A _3461_/B _3461_/A _2417_/C vdd gnd NAND3X1
X_3464_ _3464_/A _3464_/B _3464_/C _3465_/A vdd gnd OAI21X1
X_3533_ _3609_/A _4036_/Q _3533_/C _3535_/B vdd gnd OAI21X1
X_4016_ _4016_/D _4019_/CLK _4016_/Q vdd gnd DFFPOSX1
XFILL_0__3807_ vdd gnd FILL
XFILL_0_BUFX2_insert23 vdd gnd FILL
X_2346_ _2346_/A _4190_/Q _2462_/B vdd gnd AND2X2
XFILL_1__2462_ vdd gnd FILL
XFILL_0_BUFX2_insert56 vdd gnd FILL
X_2277_ _4038_/Q _4041_/Q _3508_/B vdd gnd NOR2X1
XFILL_0_BUFX2_insert45 vdd gnd FILL
XFILL_0__3669_ vdd gnd FILL
XFILL_0_BUFX2_insert34 vdd gnd FILL
XFILL_0_BUFX2_insert12 vdd gnd FILL
X_3395_ _4059_/Q _3453_/A vdd gnd INVX1
XFILL_0_BUFX2_insert89 vdd gnd FILL
XFILL_0_BUFX2_insert78 vdd gnd FILL
XFILL_0__2971_ vdd gnd FILL
X_3180_ _3180_/A _3184_/A _3181_/C vdd gnd NOR2X1
XFILL_0__3523_ vdd gnd FILL
X_2062_ _3747_/B _2188_/B _2065_/B vdd gnd NOR2X1
X_2200_ _2200_/A _2200_/B _2653_/A _2202_/C vdd gnd OAI21X1
X_2131_ _2131_/A _4124_/Q _2131_/S _2132_/B vdd gnd MUX2X1
X_2964_ _2972_/A _2964_/B _2964_/C _2965_/A vdd gnd OAI21X1
XFILL_0__2405_ vdd gnd FILL
XFILL_0__3385_ vdd gnd FILL
X_2895_ _2895_/A _2895_/B _2895_/C _2897_/B vdd gnd OAI21X1
XFILL_0__2267_ vdd gnd FILL
XFILL_0__2198_ vdd gnd FILL
X_1915_ _4185_/Q o_mem_sync vdd gnd BUFX2
X_3378_ _4131_/Q _3378_/B _3378_/C _3381_/D vdd gnd AOI21X1
X_3516_ _4041_/Q _3524_/A _3518_/A vdd gnd NOR2X1
X_3447_ _4063_/Q _3456_/A vdd gnd INVX1
X_2329_ _2543_/B _3352_/A _2521_/A vdd gnd NOR2X1
XFILL_1__2445_ vdd gnd FILL
XFILL_1__3563_ vdd gnd FILL
X_2680_ _3077_/C _3080_/C vdd gnd INVX1
XFILL_0__2121_ vdd gnd FILL
XFILL_0__2885_ vdd gnd FILL
XFILL_0__2954_ vdd gnd FILL
X_3301_ _4107_/Q _3350_/B _3301_/C _3302_/A vdd gnd OAI21X1
X_3232_ _3909_/Y _3799_/A _3382_/B _4179_/D vdd gnd MUX2X1
X_3094_ _3740_/A _3740_/B _3350_/B _3095_/A vdd gnd MUX2X1
X_3163_ _3183_/A _3183_/B _4180_/R _3186_/A vdd gnd OAI21X1
XFILL_0__3506_ vdd gnd FILL
X_2114_ _2186_/A _2114_/B _4128_/D vdd gnd NOR2X1
X_2045_ _2171_/A _4002_/Q _2046_/A vdd gnd NAND2X1
XFILL_0__2319_ vdd gnd FILL
X_2947_ _3922_/Q _2960_/A _2948_/C vdd gnd NAND2X1
XFILL_0__3299_ vdd gnd FILL
X_3996_ _3996_/D _4034_/CLK _3996_/Q vdd gnd DFFPOSX1
XFILL_0__3437_ vdd gnd FILL
X_2878_ _3954_/Q _3952_/Q _2878_/S _2880_/B vdd gnd MUX2X1
XFILL132750x68550 vdd gnd FILL
XFILL132150x64950 vdd gnd FILL
X_2801_ _2801_/A _3009_/B _3997_/D vdd gnd AND2X2
X_3850_ _3850_/D _4200_/CLK _3850_/Q vdd gnd DFFPOSX1
X_3781_ _3781_/A _3813_/B _3893_/D vdd gnd NOR2X1
XFILL_0__3222_ vdd gnd FILL
X_2732_ _2737_/A _2732_/B _2746_/A vdd gnd AND2X2
X_2594_ _2594_/A _2607_/B _2596_/A vdd gnd NAND2X1
X_2663_ _4037_/Q _2678_/B _3076_/B vdd gnd NAND2X1
XFILL_0__2104_ vdd gnd FILL
XFILL_0__2035_ vdd gnd FILL
X_4195_ _4201_/R vdd _4195_/D _4201_/CLK _4195_/Q vdd gnd DFFSR
X_3215_ _4191_/Q _3811_/Y _3772_/Y _3216_/C vdd gnd NAND3X1
XFILL_0__2799_ vdd gnd FILL
X_3077_ _3078_/B _3853_/Q _3077_/C _3078_/C vdd gnd AOI21X1
X_3146_ _3926_/A _3691_/C _3629_/A vdd gnd NOR2X1
X_2028_ _2028_/A _2181_/B _2029_/A vdd gnd NOR2X1
XFILL_1__3400_ vdd gnd FILL
X_3979_ _3979_/D _3985_/CLK _3979_/Q vdd gnd DFFPOSX1
XBUFX2_insert25 i_rst_n _4180_/R vdd gnd BUFX2
XFILL_1__3193_ vdd gnd FILL
XBUFX2_insert47 _3481_/Y _3611_/A vdd gnd BUFX2
XFILL_1__2075_ vdd gnd FILL
XBUFX2_insert36 _1956_/Y _2154_/B vdd gnd BUFX2
XBUFX2_insert14 _4187_/Q _2649_/A vdd gnd BUFX2
XFILL132750x43350 vdd gnd FILL
XBUFX2_insert58 _3143_/Y _3662_/B vdd gnd BUFX2
XFILL_0__2722_ vdd gnd FILL
XFILL_0__2584_ vdd gnd FILL
X_3000_ _3008_/A _3000_/B _3000_/C _3001_/A vdd gnd OAI21X1
X_3833_ _3833_/D _4019_/CLK _3833_/Q vdd gnd DFFPOSX1
XFILL_0__3136_ vdd gnd FILL
X_3902_ _3902_/D _3908_/CLK _3902_/Q vdd gnd DFFPOSX1
X_3764_ _3768_/Y _3766_/Y _3764_/Y vdd gnd OR2X2
X_2715_ _3103_/C _2743_/B _2741_/C vdd gnd NAND2X1
X_2577_ _2608_/B _2581_/B _2577_/C _2578_/A vdd gnd OAI21X1
X_3695_ _3913_/Y _3695_/B _3695_/C _3850_/D vdd gnd OAI21X1
XFILL_0__2018_ vdd gnd FILL
X_2646_ _2646_/A _2646_/B _3771_/A _4048_/D vdd gnd AOI21X1
XFILL_1__2762_ vdd gnd FILL
X_4178_ _4178_/D _4192_/CLK _4178_/Q vdd gnd DFFPOSX1
X_3129_ _3736_/A _3736_/B _3798_/A _3130_/A vdd gnd MUX2X1
XFILL_1__3176_ vdd gnd FILL
X_2500_ _2500_/A _2559_/B vdd gnd INVX1
X_2431_ _3850_/Q _2431_/B _2432_/A vdd gnd NAND2X1
X_3480_ _3480_/A _3481_/B vdd gnd INVX1
X_4032_ _4032_/D _4032_/CLK _4032_/Q vdd gnd DFFPOSX1
X_2362_ _2374_/B _2375_/C vdd gnd INVX1
XFILL_0__2705_ vdd gnd FILL
X_2293_ _2431_/B _3248_/A _4179_/Q _2294_/A vdd gnd AOI21X1
XFILL_0__3754_ vdd gnd FILL
X_4101_ _4101_/D _4101_/CLK _4101_/Q vdd gnd DFFPOSX1
XFILL_0__2636_ vdd gnd FILL
XFILL_1__3030_ vdd gnd FILL
XFILL_0__2498_ vdd gnd FILL
X_3816_ _3816_/A _3816_/B _3816_/S _3844_/D vdd gnd MUX2X1
X_3747_ _3747_/A _3747_/B _3747_/S _3972_/D vdd gnd MUX2X1
X_2629_ _3839_/Q _3106_/A vdd gnd INVX1
X_3678_ _3680_/C _3680_/B _3678_/C _3680_/D _3879_/D vdd gnd OAI22X1
XFILL_0_CLKBUF1_insert133 vdd gnd FILL
XFILL_0_CLKBUF1_insert166 vdd gnd FILL
XFILL_0_CLKBUF1_insert144 vdd gnd FILL
XFILL_0_CLKBUF1_insert155 vdd gnd FILL
XFILL_1__3228_ vdd gnd FILL
XFILL_0_CLKBUF1_insert188 vdd gnd FILL
X_2980_ _2992_/A _2980_/B _2980_/C _2981_/A vdd gnd OAI21X1
XFILL_0__2352_ vdd gnd FILL
XFILL_0__2421_ vdd gnd FILL
X_3601_ _3605_/A _3994_/Q _3601_/C _3603_/B vdd gnd OAI21X1
X_1931_ _4169_/Q _3698_/A vdd gnd INVX1
X_2414_ _2414_/A _3022_/B _4191_/Q _2424_/C vdd gnd OAI21X1
X_3463_ _4055_/Q _3464_/C vdd gnd INVX1
X_3532_ _3597_/A _3736_/B _3533_/C vdd gnd NAND2X1
X_3394_ _4119_/Q _3398_/B vdd gnd INVX1
XFILL_0__2619_ vdd gnd FILL
X_4015_ _4015_/D _4189_/CLK _4015_/Q vdd gnd DFFPOSX1
X_2345_ _4178_/Q _2347_/C _2422_/A vdd gnd NOR2X1
XFILL_0__3737_ vdd gnd FILL
X_2276_ _4045_/Q _3507_/A vdd gnd INVX1
XFILL_0__1998_ vdd gnd FILL
XFILL_1__3013_ vdd gnd FILL
XFILL_1__2392_ vdd gnd FILL
XFILL_0__1921_ vdd gnd FILL
X_2061_ _4140_/Q _3747_/B vdd gnd INVX1
X_2130_ _2155_/C _2130_/B _2130_/C _2131_/A vdd gnd OAI21X1
XFILL_0__3453_ vdd gnd FILL
X_2963_ _3914_/Q _2972_/A _2964_/C vdd gnd NAND2X1
XFILL_0__2335_ vdd gnd FILL
X_1914_ _2498_/Y o_rf_mosi vdd gnd BUFX2
XFILL_0__2266_ vdd gnd FILL
X_2894_ _2895_/A _2898_/A _2894_/C _2895_/C vdd gnd OAI21X1
X_3515_ _4038_/Q _3524_/A vdd gnd INVX1
X_2328_ _2341_/B _2494_/A vdd gnd INVX1
X_3377_ _3380_/B _3378_/C vdd gnd INVX1
X_3446_ _3448_/B _3446_/B _3446_/S _4065_/D vdd gnd MUX2X1
XFILL_1__3700_ vdd gnd FILL
X_2259_ _4178_/Q _4193_/Q _2264_/A vdd gnd NAND2X1
XFILL_1__3493_ vdd gnd FILL
XFILL_0_BUFX2_insert5 vdd gnd FILL
XFILL_0__2051_ vdd gnd FILL
XFILL_0__2953_ vdd gnd FILL
X_3300_ _3350_/B _3731_/A _3301_/C vdd gnd NAND2X1
X_3231_ _4148_/Q _3286_/A _3231_/C _3799_/A vdd gnd OAI21X1
X_3162_ _3162_/A _3162_/B _4202_/D vdd gnd AND2X2
X_3093_ _4195_/Q _3740_/A vdd gnd INVX1
X_2113_ _2113_/A _4128_/Q _2158_/S _2114_/B vdd gnd MUX2X1
X_2044_ _3749_/B _2170_/B _2047_/B vdd gnd NOR2X1
XFILL_0__2249_ vdd gnd FILL
X_3995_ _3995_/D _3997_/CLK _3995_/Q vdd gnd DFFPOSX1
XFILL_0__3367_ vdd gnd FILL
X_2877_ _2877_/A _2885_/B _3958_/D vdd gnd AND2X2
X_2946_ _3920_/Q _3918_/Q _2950_/S _2948_/B vdd gnd MUX2X1
XFILL_1__3545_ vdd gnd FILL
X_3429_ _4082_/Q _3432_/B vdd gnd INVX1
XFILL_1__2427_ vdd gnd FILL
X_2731_ _2736_/A _4089_/Q _2732_/B vdd gnd AND2X2
X_2800_ _2903_/A _2800_/B _2800_/C _2801_/A vdd gnd OAI21X1
XFILL_0__3083_ vdd gnd FILL
XFILL_0__3152_ vdd gnd FILL
X_3780_ _3893_/Q _3783_/B _3781_/A vdd gnd NOR2X1
XFILL_0__2103_ vdd gnd FILL
XFILL_0_BUFX2_insert120 vdd gnd FILL
XFILL132750x129750 vdd gnd FILL
X_2593_ _2593_/A _2758_/A _4070_/D vdd gnd AND2X2
XFILL_0_BUFX2_insert175 vdd gnd FILL
X_2662_ _2685_/S _2678_/B vdd gnd INVX1
XFILL_0__2867_ vdd gnd FILL
XFILL_0__2936_ vdd gnd FILL
X_3145_ _3145_/A _3147_/B vdd gnd INVX1
X_3214_ _3214_/A _3214_/B _3214_/Y vdd gnd NOR2X1
X_4194_ _4194_/D _4200_/CLK _4194_/Q vdd gnd DFFPOSX1
XFILL_1__3330_ vdd gnd FILL
X_3076_ _3807_/A _3076_/B _3076_/C _3855_/D vdd gnd AOI21X1
X_2027_ _2180_/A _3998_/Q _2028_/A vdd gnd NAND2X1
XBUFX2_insert37 _2905_/Y _3008_/A vdd gnd BUFX2
X_2929_ _2929_/A _3976_/R _3934_/D vdd gnd AND2X2
XBUFX2_insert26 i_rst_n _4197_/R vdd gnd BUFX2
XBUFX2_insert48 _3481_/Y _3603_/A vdd gnd BUFX2
XBUFX2_insert59 _3143_/Y _3672_/B vdd gnd BUFX2
XBUFX2_insert15 _4187_/Q _2180_/A vdd gnd BUFX2
X_3978_ _3978_/D _4119_/CLK _3978_/Q vdd gnd DFFPOSX1
XFILL_1__3528_ vdd gnd FILL
XFILL_0__3770_ vdd gnd FILL
XFILL_0__2652_ vdd gnd FILL
XFILL_0__2583_ vdd gnd FILL
X_3901_ _3901_/A _3909_/Y _3905_/Y _3901_/Y vdd gnd NAND3X1
X_2714_ _2714_/A _2714_/B _3103_/B _2743_/B vdd gnd AOI21X1
XFILL_0__3066_ vdd gnd FILL
XFILL_0__3204_ vdd gnd FILL
X_3694_ _3850_/Q _3913_/Y _3695_/C vdd gnd NAND2X1
X_3832_ _4180_/R vdd _3832_/D _4193_/CLK _3832_/Q vdd gnd DFFSR
X_3763_ _4078_/Q _3764_/Y _3763_/Y vdd gnd NOR2X1
X_2576_ _4083_/Q _3071_/C _2577_/C vdd gnd NOR2X1
X_2645_ _2645_/A _2645_/B _2645_/C _2646_/A vdd gnd NAND3X1
X_4177_ _4177_/D _4191_/CLK _4177_/Q vdd gnd DFFPOSX1
X_3128_ _3824_/Q _3736_/A vdd gnd INVX1
X_3059_ _3062_/B _3863_/Q _3067_/B vdd gnd OR2X2
XFILL_1__2057_ vdd gnd FILL
X_2361_ _3457_/B _3905_/Y _3459_/B _2374_/B vdd gnd NAND3X1
X_2430_ _3460_/B _3168_/B vdd gnd INVX1
X_4031_ _4031_/D _4052_/CLK _4031_/Q vdd gnd DFFPOSX1
X_2292_ _4188_/Q _3905_/Y _3248_/A vdd gnd NOR2X1
X_4100_ _4100_/D _4100_/CLK _4100_/Q vdd gnd DFFPOSX1
XFILL_0__3684_ vdd gnd FILL
XFILL_0__2566_ vdd gnd FILL
XFILL_0__3118_ vdd gnd FILL
X_3746_ _3746_/A _3746_/B _3750_/S _3976_/D vdd gnd MUX2X1
X_3815_ _4046_/Q _3816_/B vdd gnd INVX1
X_3677_ _3879_/Q _3680_/C vdd gnd INVX1
XFILL_1__2744_ vdd gnd FILL
X_2559_ _2559_/A _2559_/B _4091_/D vdd gnd NOR2X1
X_2628_ _3837_/Q _3033_/A vdd gnd INVX1
XFILL_1__3158_ vdd gnd FILL
XFILL131850x68550 vdd gnd FILL
XFILL_0__2420_ vdd gnd FILL
X_1930_ _4167_/Q _3696_/A vdd gnd INVX1
XFILL_0__2282_ vdd gnd FILL
X_3600_ _3609_/A _3753_/B _3601_/C vdd gnd NAND2X1
X_3531_ _3611_/A _3531_/B _3531_/C _4036_/D vdd gnd AOI21X1
X_2413_ _4005_/Q _2414_/A vdd gnd INVX1
X_3393_ _3393_/A _3393_/B _3393_/C _4115_/D vdd gnd OAI21X1
X_2344_ _3877_/Q _3802_/A vdd gnd INVX1
X_3462_ _4055_/Q _3462_/B _3462_/C _3471_/A vdd gnd NAND3X1
XFILL_0__3805_ vdd gnd FILL
XFILL_0__2618_ vdd gnd FILL
X_4014_ _4014_/D _4040_/CLK _4014_/Q vdd gnd DFFPOSX1
XFILL_0_BUFX2_insert25 vdd gnd FILL
XFILL_0__3598_ vdd gnd FILL
X_2275_ _4043_/Q _3519_/A vdd gnd INVX1
XFILL_0_BUFX2_insert47 vdd gnd FILL
XFILL_0_BUFX2_insert58 vdd gnd FILL
XFILL_0_BUFX2_insert36 vdd gnd FILL
XFILL_0__3667_ vdd gnd FILL
XFILL_0_BUFX2_insert14 vdd gnd FILL
X_3729_ _3729_/A _3729_/B _3747_/S _3838_/D vdd gnd MUX2X1
XFILL_1__2727_ vdd gnd FILL
XFILL_0__2403_ vdd gnd FILL
X_2060_ _2177_/A _2060_/B _4140_/D vdd gnd NOR2X1
XFILL_0__3521_ vdd gnd FILL
X_2893_ _3948_/Q _2895_/A _2894_/C vdd gnd NAND2X1
X_1913_ _2244_/Y o_rf_sck vdd gnd BUFX2
X_2962_ _3912_/Q _3910_/Q _2986_/S _2964_/B vdd gnd MUX2X1
XFILL_0__3383_ vdd gnd FILL
X_3445_ _4065_/Q _3448_/B vdd gnd INVX1
X_3514_ _4041_/Q _3525_/A vdd gnd INVX1
XFILL_1__1960_ vdd gnd FILL
XFILL_0__2196_ vdd gnd FILL
X_2327_ _4081_/Q _2468_/C _2341_/B vdd gnd NOR2X1
X_3376_ _4190_/Q _4189_/Q _3376_/C _3380_/B vdd gnd OAI21X1
X_2258_ _3487_/B _2270_/C vdd gnd INVX1
XFILL132750x28950 vdd gnd FILL
XFILL_0__3719_ vdd gnd FILL
XFILL_1__2374_ vdd gnd FILL
X_2189_ _2649_/A _4041_/Q _2190_/A vdd gnd NAND2X1
XFILL_0_BUFX2_insert6 vdd gnd FILL
XFILL_0__2883_ vdd gnd FILL
X_3230_ _3333_/A _3751_/A _3231_/C vdd gnd NAND2X1
X_3161_ _3771_/A _3774_/Y _3162_/B vdd gnd NOR2X1
X_2112_ _2157_/A _2112_/B _2112_/C _2113_/A vdd gnd OAI21X1
X_3092_ _3845_/Q _3323_/C _3096_/B vdd gnd NAND2X1
XFILL_0__3504_ vdd gnd FILL
XFILL_0__3435_ vdd gnd FILL
X_2043_ _4144_/Q _3749_/B vdd gnd INVX1
X_2876_ _2880_/A _2876_/B _2876_/C _2877_/A vdd gnd OAI21X1
X_2945_ _2945_/A _4197_/R _3925_/D vdd gnd AND2X2
XFILL_0__2317_ vdd gnd FILL
XFILL_0__3297_ vdd gnd FILL
X_3994_ _3994_/D _4034_/CLK _3994_/Q vdd gnd DFFPOSX1
XFILL_0__2179_ vdd gnd FILL
XFILL_1__1943_ vdd gnd FILL
X_3428_ _3430_/B _3428_/B _3430_/S _4084_/D vdd gnd MUX2X1
X_3359_ _3359_/A _3359_/B _3393_/A _3359_/D _4133_/D vdd gnd AOI22X1
XFILL_1__3475_ vdd gnd FILL
XFILL_1__2357_ vdd gnd FILL
XFILL_0__3220_ vdd gnd FILL
X_2730_ _2730_/A _2730_/B _2730_/C _2736_/A vdd gnd NAND3X1
X_2661_ _3901_/A _3152_/A _3077_/C vdd gnd NAND2X1
XFILL_0__3151_ vdd gnd FILL
XFILL_0__2033_ vdd gnd FILL
X_2592_ _2592_/A _2592_/B _2592_/C _2593_/A vdd gnd OAI21X1
XFILL_0__2935_ vdd gnd FILL
XFILL_0__2797_ vdd gnd FILL
X_3075_ _3807_/A _3076_/B _3080_/C _3076_/C vdd gnd OAI21X1
X_4193_ _4193_/D _4193_/CLK _4193_/Q vdd gnd DFFPOSX1
X_3144_ _3144_/A _4198_/Q _3148_/D vdd gnd AND2X2
X_3213_ _4185_/Q _3214_/B vdd gnd INVX1
X_3977_ _3977_/D _3977_/CLK _3977_/Q vdd gnd DFFPOSX1
XFILL_0__3349_ vdd gnd FILL
XFILL_0__3418_ vdd gnd FILL
X_2026_ _3751_/B _2188_/B _2029_/B vdd gnd NOR2X1
XFILL_1__2211_ vdd gnd FILL
X_2859_ _3967_/Q _2900_/B _2860_/C vdd gnd NAND2X1
XBUFX2_insert27 i_rst_n _2997_/B vdd gnd BUFX2
XBUFX2_insert38 _2905_/Y _3027_/A vdd gnd BUFX2
X_2928_ _2928_/A _2928_/B _2928_/C _2929_/A vdd gnd OAI21X1
XBUFX2_insert49 _3481_/Y _3599_/A vdd gnd BUFX2
XBUFX2_insert16 _4187_/Q _2171_/A vdd gnd BUFX2
XFILL132450x93750 vdd gnd FILL
XFILL_0__2720_ vdd gnd FILL
X_3900_ _3900_/D _3908_/CLK _3900_/Q vdd gnd DFFPOSX1
X_3831_ _3831_/D _4172_/CLK _3831_/Q vdd gnd DFFPOSX1
X_2713_ _2713_/A _2713_/B _2714_/A vdd gnd NOR2X1
XFILL_0__3134_ vdd gnd FILL
X_3693_ _3913_/Y _3693_/B _3693_/C _3854_/D vdd gnd OAI21X1
X_3762_ _3763_/Y _3762_/Y vdd gnd INVX1
X_2644_ _3804_/Y _3803_/Y _3218_/B _2645_/B vdd gnd AOI21X1
XFILL_0__2016_ vdd gnd FILL
X_2575_ _2575_/A _4085_/D vdd gnd INVX1
XFILL_0__2918_ vdd gnd FILL
XFILL_1__2691_ vdd gnd FILL
X_3127_ _3829_/Q _3344_/C _3131_/B vdd gnd NAND2X1
XFILL_1__3312_ vdd gnd FILL
X_3058_ _3865_/Q _3058_/B _3863_/Q _3060_/B vdd gnd OAI21X1
XFILL132450x25350 vdd gnd FILL
X_4176_ _4176_/D _4183_/CLK _4176_/Q vdd gnd DFFPOSX1
X_2009_ _2153_/A _3994_/Q _2010_/A vdd gnd NAND2X1
XFILL_1__2889_ vdd gnd FILL
X_2360_ _4189_/Q _3459_/B vdd gnd INVX1
X_2291_ _4178_/Q _3708_/A _2431_/B vdd gnd NOR2X1
XFILL_0__3752_ vdd gnd FILL
XFILL_0__2634_ vdd gnd FILL
XFILL_0__2703_ vdd gnd FILL
X_4030_ _4030_/D _4030_/CLK _4030_/Q vdd gnd DFFPOSX1
XFILL_0__2496_ vdd gnd FILL
X_3814_ _3814_/A _3814_/B _3852_/D vdd gnd NOR2X1
X_2627_ _4050_/Q _2712_/B vdd gnd INVX1
XFILL_0__3048_ vdd gnd FILL
X_3745_ _3745_/A _3745_/B _3747_/S _4175_/D vdd gnd MUX2X1
X_3676_ _3678_/C _3680_/B _3676_/C _3680_/D _3883_/D vdd gnd OAI22X1
X_2558_ _2758_/A _4091_/Q _2559_/A vdd gnd NAND2X1
X_2489_ _4042_/Q _3807_/B vdd gnd INVX1
XFILL_1__2674_ vdd gnd FILL
XFILL_1__3792_ vdd gnd FILL
X_4159_ _4159_/D _3214_/A _4159_/Q vdd gnd DFFPOSX1
XFILL_0_CLKBUF1_insert146 vdd gnd FILL
XFILL_0_CLKBUF1_insert168 vdd gnd FILL
XFILL_1__3088_ vdd gnd FILL
XFILL_0_CLKBUF1_insert135 vdd gnd FILL
XFILL_0_CLKBUF1_insert157 vdd gnd FILL
XFILL_0__2350_ vdd gnd FILL
X_3461_ _3461_/A _3461_/B _3461_/C _3470_/B vdd gnd AOI21X1
X_3530_ _4036_/Q _3611_/A _3531_/C vdd gnd NOR2X1
X_2343_ _2583_/B _2343_/B _2498_/B vdd gnd NAND2X1
X_3392_ _4115_/Q _3393_/A _3393_/C vdd gnd NAND2X1
XFILL_0__3735_ vdd gnd FILL
X_2412_ _3909_/Y _2412_/B _3692_/B vdd gnd NAND2X1
X_4013_ _4013_/D _4030_/CLK _4013_/Q vdd gnd DFFPOSX1
X_2274_ _4049_/Q _3496_/B vdd gnd INVX1
XFILL_0_BUFX2_insert15 vdd gnd FILL
XFILL_0__1996_ vdd gnd FILL
XFILL_0__2548_ vdd gnd FILL
XFILL_0_BUFX2_insert37 vdd gnd FILL
XFILL_0_BUFX2_insert59 vdd gnd FILL
XFILL_0__3666_ vdd gnd FILL
X_1989_ _4157_/Q _3756_/B vdd gnd INVX1
X_3728_ _3728_/A _3728_/B _3755_/S _3840_/D vdd gnd MUX2X1
X_3659_ _3915_/Q _3662_/C vdd gnd INVX1
XFILL132150x90150 vdd gnd FILL
XFILL_0__3451_ vdd gnd FILL
X_2892_ _3946_/Q _2898_/A vdd gnd INVX1
X_1912_ _4087_/Q o_rf_sync vdd gnd BUFX2
XFILL_0__2333_ vdd gnd FILL
XFILL_0__2264_ vdd gnd FILL
X_2961_ _2961_/A _4197_/R _3916_/D vdd gnd AND2X2
X_3444_ _3446_/B _3444_/B _3446_/S _4067_/D vdd gnd MUX2X1
X_3513_ _3519_/A _3522_/B _3513_/C _3513_/D _4043_/D vdd gnd OAI22X1
XFILL_1__2511_ vdd gnd FILL
X_2326_ _4083_/Q _2468_/C vdd gnd INVX1
X_3375_ _3457_/B _3459_/B _3376_/C vdd gnd NAND2X1
X_2257_ _4193_/Q _3905_/Y _3487_/B vdd gnd NOR2X1
XFILL_0__3649_ vdd gnd FILL
X_2188_ _3733_/B _2188_/B _2191_/B vdd gnd NOR2X1
XFILL_1__2709_ vdd gnd FILL
XFILL_0__2951_ vdd gnd FILL
X_3091_ _3258_/C _3091_/B _3141_/C _3847_/D vdd gnd AOI21X1
XFILL_0__3503_ vdd gnd FILL
X_2111_ _4094_/Q _3937_/Q _2120_/S _2112_/B vdd gnd MUX2X1
X_2042_ _2177_/A _2042_/B _4144_/D vdd gnd NOR2X1
X_3160_ _3776_/Y _3769_/Y _3804_/Y _3162_/A vdd gnd OAI21X1
X_3993_ _3993_/D _4003_/CLK _3993_/Q vdd gnd DFFPOSX1
XFILL_0__3365_ vdd gnd FILL
X_2875_ _3958_/Q _2880_/A _2876_/C vdd gnd NAND2X1
XFILL_0__2247_ vdd gnd FILL
X_2944_ _2960_/A _2944_/B _2944_/C _2945_/A vdd gnd OAI21X1
XFILL_0__2178_ vdd gnd FILL
XFILL_1__2991_ vdd gnd FILL
X_3358_ _4135_/Q _3358_/B _3358_/C _3359_/B vdd gnd OAI21X1
X_3427_ _4084_/Q _3430_/B vdd gnd INVX1
XFILL_1__3612_ vdd gnd FILL
X_3289_ _4158_/Q _3309_/B _3289_/C _3291_/B vdd gnd OAI21X1
X_2309_ _4191_/Q _3200_/A vdd gnd INVX1
X_2660_ _2660_/A _2660_/B _3141_/C _4044_/D vdd gnd AOI21X1
XFILL_0__3081_ vdd gnd FILL
XFILL_0_BUFX2_insert111 vdd gnd FILL
XFILL_0_BUFX2_insert177 vdd gnd FILL
XFILL_0_BUFX2_insert122 vdd gnd FILL
XFILL_0_BUFX2_insert100 vdd gnd FILL
XFILL_0__2101_ vdd gnd FILL
X_2591_ _2608_/A _2608_/B _4070_/Q _2592_/C vdd gnd OAI21X1
XFILL_0__2865_ vdd gnd FILL
X_3212_ _3382_/B _3791_/A _3212_/C _4188_/D vdd gnd OAI21X1
X_3074_ _3152_/A _3074_/B _3926_/A _3857_/D vdd gnd AOI21X1
X_4192_ _4192_/D _4192_/CLK _4192_/Q vdd gnd DFFPOSX1
X_2025_ _4148_/Q _3751_/B vdd gnd INVX1
X_3143_ _3913_/Y _3466_/C _4180_/R _3143_/Y vdd gnd OAI21X1
X_2927_ _3934_/Q _2928_/A _2928_/C vdd gnd NAND2X1
X_3976_ _3976_/R vdd _3976_/D _4197_/CLK _3976_/Q vdd gnd DFFSR
XFILL_0__3279_ vdd gnd FILL
XFILL_1__2141_ vdd gnd FILL
XBUFX2_insert28 i_rst_n _2758_/A vdd gnd BUFX2
X_2858_ _3965_/Q _3963_/Q _2878_/S _2860_/B vdd gnd MUX2X1
XBUFX2_insert17 _4016_/Q _2607_/A vdd gnd BUFX2
X_2789_ _2789_/A _3976_/R _4003_/D vdd gnd AND2X2
XBUFX2_insert39 _2905_/Y _2928_/A vdd gnd BUFX2
XFILL_1__1925_ vdd gnd FILL
XFILL_1__3457_ vdd gnd FILL
XFILL_1__2339_ vdd gnd FILL
XFILL_0__2581_ vdd gnd FILL
XFILL_0__2650_ vdd gnd FILL
X_3830_ _4201_/R vdd _3830_/D _4166_/CLK _3830_/Q vdd gnd DFFSR
XFILL_0__3202_ vdd gnd FILL
X_3761_ _3762_/Y _3765_/Y _3770_/Y _4078_/D vdd gnd AOI21X1
X_2574_ _2758_/A _2574_/B _2574_/C _2575_/A vdd gnd NAND3X1
X_2712_ _3103_/C _2712_/B _2713_/B vdd gnd NAND2X1
XFILL_0__3064_ vdd gnd FILL
X_3692_ _3913_/Y _3692_/B _3693_/C vdd gnd NAND2X1
X_2643_ _2643_/A _3218_/B vdd gnd INVX1
XFILL_0__2015_ vdd gnd FILL
XFILL_0__2848_ vdd gnd FILL
X_4175_ _4201_/R vdd _4175_/D _4201_/CLK _4175_/Q vdd gnd DFFSR
XFILL_0__3897_ vdd gnd FILL
X_3126_ _3326_/C _3126_/B _3141_/C _3831_/D vdd gnd AOI21X1
X_3057_ _3152_/A _3062_/B _3926_/A _3865_/D vdd gnd AOI21X1
XFILL_1__3242_ vdd gnd FILL
XFILL_0__2779_ vdd gnd FILL
X_2008_ _3753_/B _2179_/B _2011_/B vdd gnd NOR2X1
X_3959_ _3976_/R vdd _3959_/D _4197_/CLK _3959_/Q vdd gnd DFFSR
XFILL131850x28950 vdd gnd FILL
XFILL_0__2702_ vdd gnd FILL
X_2290_ _3609_/A _3526_/S vdd gnd INVX2
XFILL_0__3682_ vdd gnd FILL
XFILL_0__2564_ vdd gnd FILL
XFILL_0__2495_ vdd gnd FILL
XFILL_0__3116_ vdd gnd FILL
X_3744_ _3744_/A _3744_/B _3755_/S _4180_/D vdd gnd MUX2X1
X_3813_ _3852_/Q _3813_/B _3814_/B vdd gnd NOR2X1
X_2557_ _2592_/B _2557_/B _3071_/C _4092_/D vdd gnd AOI21X1
X_2626_ _2626_/A _2626_/B _3141_/C _4052_/D vdd gnd AOI21X1
X_3675_ _3883_/Q _3678_/C vdd gnd INVX1
X_2488_ _3878_/Q _2509_/B _2488_/C _2592_/A vdd gnd OAI21X1
X_4158_ _4158_/D _4173_/CLK _4158_/Q vdd gnd DFFPOSX1
X_4089_ _4089_/D _4089_/CLK _4089_/Q vdd gnd DFFPOSX1
X_3109_ _3109_/A _3121_/A _3839_/D vdd gnd NOR2X1
XFILL_0_CLKBUF1_insert147 vdd gnd FILL
XFILL_0_CLKBUF1_insert169 vdd gnd FILL
XFILL_0__2280_ vdd gnd FILL
X_3391_ _4149_/Q _3391_/B _3391_/S _3393_/B vdd gnd MUX2X1
X_2411_ _2421_/C _2420_/A vdd gnd INVX1
X_3460_ _3460_/A _3460_/B _3905_/Y _3461_/C vdd gnd OAI21X1
X_2342_ _3809_/A _2342_/B _2342_/C _2343_/B vdd gnd OAI21X1
XFILL_0_BUFX2_insert27 vdd gnd FILL
X_2273_ _3237_/A _3151_/A _3466_/C _3488_/A vdd gnd OAI21X1
X_4012_ _4012_/D _4027_/CLK _4012_/Q vdd gnd DFFPOSX1
XFILL_0__3803_ vdd gnd FILL
XFILL_0__2478_ vdd gnd FILL
XFILL_0__2616_ vdd gnd FILL
XFILL_0_BUFX2_insert49 vdd gnd FILL
XFILL_0__3596_ vdd gnd FILL
X_3727_ _3727_/A _3727_/B _3747_/S _3842_/D vdd gnd MUX2X1
X_1988_ _2177_/A _1988_/B _4157_/D vdd gnd NOR2X1
X_2609_ _2609_/A _2609_/B _3071_/C _4056_/D vdd gnd AOI21X1
XFILL_1__3774_ vdd gnd FILL
X_3658_ _3660_/C _3662_/B _3658_/C _3662_/D _3919_/D vdd gnd OAI22X1
X_3589_ _3620_/A _4000_/Q _3589_/C _3591_/B vdd gnd OAI21X1
XFILL_1__2656_ vdd gnd FILL
XFILL_0__2332_ vdd gnd FILL
X_2960_ _2960_/A _2960_/B _2960_/C _2961_/A vdd gnd OAI21X1
XFILL_0__3381_ vdd gnd FILL
XFILL_0__2401_ vdd gnd FILL
X_2891_ _2891_/A _2891_/B _3038_/C _3952_/D vdd gnd AOI21X1
XFILL_0__2194_ vdd gnd FILL
X_3374_ _4125_/Q _3385_/A vdd gnd INVX1
X_3443_ _4067_/Q _3446_/B vdd gnd INVX1
X_3512_ _3526_/S _4107_/Q _3522_/B _3513_/D vdd gnd OAI21X1
X_2256_ _2516_/B _2509_/B vdd gnd INVX2
X_2325_ _2509_/B _2482_/B _2573_/B _2604_/A _2336_/A vdd gnd OAI22X1
X_2187_ _4111_/Q _3733_/B vdd gnd INVX1
XFILL_0__3717_ vdd gnd FILL
XFILL_0__1978_ vdd gnd FILL
XFILL_0__3579_ vdd gnd FILL
XFILL_1__3757_ vdd gnd FILL
XFILL_0_BUFX2_insert8 vdd gnd FILL
XFILL_0__2881_ vdd gnd FILL
X_3090_ _3090_/A _3310_/B _3258_/C vdd gnd NAND2X1
X_2110_ _2110_/A _2110_/B _2157_/A _2112_/C vdd gnd OAI21X1
XFILL_0__3433_ vdd gnd FILL
X_2041_ _2041_/A _4144_/Q _2131_/S _2042_/B vdd gnd MUX2X1
X_2943_ _3925_/Q _2972_/A _2944_/C vdd gnd NAND2X1
XFILL_0__3295_ vdd gnd FILL
XFILL_0__2315_ vdd gnd FILL
X_3992_ _3992_/D _4027_/CLK _3992_/Q vdd gnd DFFPOSX1
X_2874_ _3956_/Q _3954_/Q _2878_/S _2876_/B vdd gnd MUX2X1
X_3357_ _3372_/B _3802_/B _3359_/A vdd gnd NAND2X1
X_2308_ _4179_/Q _3457_/B _2402_/B vdd gnd NOR2X1
X_3426_ _3428_/B _3426_/B _3430_/S _4086_/D vdd gnd MUX2X1
X_3288_ _3288_/A _3309_/B _3289_/C vdd gnd NAND2X1
X_2239_ _2239_/A _4099_/Q _2654_/S _2240_/B vdd gnd MUX2X1
XFILL_1__2286_ vdd gnd FILL
X_2590_ _2590_/A _2758_/A _4072_/D vdd gnd AND2X2
XFILL_0__2031_ vdd gnd FILL
XFILL_0__2933_ vdd gnd FILL
X_4191_ _4191_/D _4191_/CLK _4191_/Q vdd gnd DFFPOSX1
X_3211_ _4157_/Q _3235_/B _3211_/C _3791_/A vdd gnd OAI21X1
X_3142_ _3823_/Q _3685_/C vdd gnd INVX1
XFILL_0__2795_ vdd gnd FILL
X_3073_ _3073_/A _4035_/Q _3073_/S _3074_/B vdd gnd MUX2X1
XFILL_0__3416_ vdd gnd FILL
X_2024_ _2186_/A _2024_/B _4148_/D vdd gnd NOR2X1
X_3975_ _3975_/D _3985_/CLK _3975_/Q vdd gnd DFFPOSX1
X_2857_ _2857_/A _2885_/B _3969_/D vdd gnd AND2X2
XBUFX2_insert18 _4016_/Q _2516_/B vdd gnd BUFX2
XFILL_0__3347_ vdd gnd FILL
X_2926_ _3932_/Q _3929_/Q _3006_/S _2928_/B vdd gnd MUX2X1
XBUFX2_insert29 i_rst_n _3947_/S vdd gnd BUFX2
XFILL_1__2071_ vdd gnd FILL
XFILL_0__2229_ vdd gnd FILL
X_2788_ _2796_/A _2788_/B _2788_/C _2789_/A vdd gnd OAI21X1
XFILL_1__2973_ vdd gnd FILL
X_3409_ _4104_/Q _3412_/B vdd gnd INVX1
XFILL_1__3387_ vdd gnd FILL
XFILL_1__2269_ vdd gnd FILL
X_2711_ _3033_/A _3106_/A _2713_/A vdd gnd NAND2X1
XFILL_0__3063_ vdd gnd FILL
XFILL_0__3132_ vdd gnd FILL
X_3760_ _3760_/A _3760_/B _3760_/S _3930_/D vdd gnd MUX2X1
X_2573_ _2573_/A _2573_/B _2735_/B _2574_/B vdd gnd OAI21X1
X_3691_ _3691_/A _3691_/B _3691_/C _4154_/D vdd gnd AOI21X1
X_2642_ _2642_/A _3768_/Y _2645_/C vdd gnd NOR2X1
XFILL_0__2847_ vdd gnd FILL
XFILL_0__2916_ vdd gnd FILL
X_3125_ _3125_/A _3351_/B _3326_/C vdd gnd NAND2X1
X_4174_ _4174_/D _4196_/CLK _4174_/Q vdd gnd DFFPOSX1
X_3056_ _4035_/Q _3073_/S _3056_/C _3062_/B vdd gnd OAI21X1
X_2007_ _4152_/Q _3753_/B vdd gnd INVX1
X_3958_ _3958_/D _3977_/CLK _3958_/Q vdd gnd DFFPOSX1
X_2909_ _2909_/A _3976_/R _3944_/D vdd gnd AND2X2
X_3889_ _3889_/D _4101_/CLK _3889_/Q vdd gnd DFFPOSX1
XFILL_1__2123_ vdd gnd FILL
XFILL132750x79350 vdd gnd FILL
XFILL132150x75750 vdd gnd FILL
XFILL_1__2956_ vdd gnd FILL
XFILL_0__2632_ vdd gnd FILL
XFILL_0__3750_ vdd gnd FILL
XFILL_0__3046_ vdd gnd FILL
X_3812_ _3812_/A _3812_/B _3816_/S _3856_/D vdd gnd OAI21X1
X_3743_ _3743_/A _3743_/B _3760_/S _4182_/D vdd gnd MUX2X1
X_3674_ _3676_/C _3680_/B _3674_/C _3680_/D _3887_/D vdd gnd OAI22X1
X_2487_ _3081_/A _2509_/B _2488_/C vdd gnd NAND2X1
X_2556_ _2607_/A _2556_/B _4092_/Q _2557_/B vdd gnd OAI21X1
XFILL_1__2810_ vdd gnd FILL
X_2625_ _3386_/B _3369_/A _2626_/A vdd gnd NAND2X1
X_3108_ _3113_/B _3108_/B _3109_/A vdd gnd OR2X2
X_4088_ _4088_/D _4094_/CLK _4088_/Q vdd gnd DFFPOSX1
X_4157_ _4157_/D _4157_/CLK _4157_/Q vdd gnd DFFPOSX1
X_3039_ _3831_/Q _3849_/Q _3841_/Q _3041_/B vdd gnd MUX2X1
XFILL_0_CLKBUF1_insert159 vdd gnd FILL
XFILL132750x54150 vdd gnd FILL
XFILL132150x50550 vdd gnd FILL
XFILL_0_CLKBUF1_insert137 vdd gnd FILL
XFILL_1__3224_ vdd gnd FILL
XFILL_1__2106_ vdd gnd FILL
X_2341_ _4079_/Q _2341_/B _2342_/B vdd gnd NAND2X1
X_3390_ _3746_/A _3746_/B _3390_/S _3391_/B vdd gnd MUX2X1
X_2410_ _3170_/B _2410_/B _2421_/C vdd gnd NAND2X1
XFILL_0__1994_ vdd gnd FILL
XFILL_0_BUFX2_insert28 vdd gnd FILL
XFILL_0_BUFX2_insert17 vdd gnd FILL
XFILL_0_BUFX2_insert39 vdd gnd FILL
XFILL_0__3733_ vdd gnd FILL
X_4011_ _4011_/D _4030_/CLK _4011_/Q vdd gnd DFFPOSX1
X_2272_ _2378_/B _3151_/A vdd gnd INVX1
XFILL_0__3664_ vdd gnd FILL
XFILL_0__2546_ vdd gnd FILL
X_3726_ _3798_/A _3726_/B _4181_/Q _3726_/Y vdd gnd OAI21X1
X_3657_ _3919_/Q _3660_/C vdd gnd INVX1
X_1987_ _1987_/A _4157_/Q _2176_/S _1988_/B vdd gnd MUX2X1
X_2539_ _2539_/A _2539_/B _2540_/C vdd gnd NOR2X1
X_2608_ _2608_/A _2608_/B _4056_/Q _2609_/B vdd gnd OAI21X1
X_3588_ _3620_/A _3750_/B _3589_/C vdd gnd NAND2X1
XFILL_1__2586_ vdd gnd FILL
X_2890_ _3952_/Q _2900_/B _2891_/A vdd gnd NAND2X1
XFILL_0__3380_ vdd gnd FILL
XFILL_0__2262_ vdd gnd FILL
X_3511_ _3511_/A _3511_/B _3513_/C vdd gnd NOR2X1
X_2324_ _2493_/A _2573_/B vdd gnd INVX1
X_3373_ _3381_/A _3373_/B _3373_/C _3373_/D _4127_/D vdd gnd AOI22X1
X_3442_ _3444_/B _3442_/B _3446_/S _4069_/D vdd gnd MUX2X1
X_2255_ _2581_/C _2493_/C vdd gnd INVX1
XFILL_0__3647_ vdd gnd FILL
XFILL_0__3578_ vdd gnd FILL
X_2186_ _2186_/A _2186_/B _4111_/D vdd gnd NOR2X1
XFILL_1__2440_ vdd gnd FILL
X_3709_ _4078_/Q _3709_/B _3711_/A vdd gnd NAND2X1
XFILL_1__2638_ vdd gnd FILL
XFILL_0__3501_ vdd gnd FILL
X_2040_ _2182_/C _2040_/B _2040_/C _2041_/A vdd gnd OAI21X1
X_2873_ _2873_/A _2885_/B _3960_/D vdd gnd AND2X2
XFILL_0__2245_ vdd gnd FILL
X_3991_ _3991_/D _3997_/CLK _3991_/Q vdd gnd DFFPOSX1
X_2942_ _3922_/Q _3920_/Q _2950_/S _2944_/B vdd gnd MUX2X1
XFILL_0__3363_ vdd gnd FILL
XFILL_0__2176_ vdd gnd FILL
X_3356_ _3750_/A _3750_/B _3390_/S _3372_/B vdd gnd MUX2X1
X_2307_ _4188_/Q _3457_/B vdd gnd INVX2
X_3287_ _4103_/Q _3333_/A _3287_/C _3288_/A vdd gnd OAI21X1
X_3425_ _4086_/Q _3428_/B vdd gnd INVX1
XFILL_1__3541_ vdd gnd FILL
X_2238_ _2653_/A _2238_/B _2238_/C _2239_/A vdd gnd OAI21X1
XFILL_1__2423_ vdd gnd FILL
X_2169_ _4116_/Q _3735_/B vdd gnd INVX1
XFILL_1__3739_ vdd gnd FILL
XFILL_0_BUFX2_insert113 vdd gnd FILL
XFILL_0_BUFX2_insert124 vdd gnd FILL
XFILL_0_BUFX2_insert102 vdd gnd FILL
XFILL_0_BUFX2_insert179 vdd gnd FILL
XFILL_0__2863_ vdd gnd FILL
X_3141_ _3318_/C _3141_/B _3141_/C _3825_/D vdd gnd AOI21X1
X_4190_ _4190_/D _4192_/CLK _4190_/Q vdd gnd DFFPOSX1
X_3210_ _3235_/B _3756_/A _3211_/C vdd gnd NAND2X1
X_3072_ _3072_/A _3072_/B _3073_/A vdd gnd NOR2X1
XFILL_0__3415_ vdd gnd FILL
X_2023_ _2023_/A _4148_/Q _2185_/S _2024_/B vdd gnd MUX2X1
X_2856_ _2864_/A _2856_/B _2856_/C _2857_/A vdd gnd OAI21X1
XBUFX2_insert19 _4016_/Q _2543_/B vdd gnd BUFX2
X_2925_ _2925_/A _3976_/R _3936_/D vdd gnd AND2X2
XFILL_0__3277_ vdd gnd FILL
XFILL_0__2159_ vdd gnd FILL
X_3974_ _3974_/D _4071_/CLK _3974_/Q vdd gnd DFFPOSX1
X_2787_ _4003_/Q _2796_/A _2788_/C vdd gnd NAND2X1
X_3408_ _3410_/B _3408_/B _3448_/S _4106_/D vdd gnd MUX2X1
X_3339_ _3352_/A _3393_/A _3345_/C vdd gnd NAND2X1
XFILL_0__3200_ vdd gnd FILL
X_2710_ _3833_/Q _3835_/Q _2714_/B vdd gnd NOR2X1
X_3690_ _3690_/A _3691_/B vdd gnd INVX1
XFILL_0__2013_ vdd gnd FILL
X_2572_ _4085_/Q _2735_/B vdd gnd INVX1
X_2641_ _2642_/A _2646_/B vdd gnd INVX1
X_4173_ _4173_/D _4173_/CLK _4173_/Q vdd gnd DFFPOSX1
X_3055_ _3865_/Q _3056_/C vdd gnd INVX1
XFILL_0__2777_ vdd gnd FILL
X_3124_ _3737_/A _3737_/B _3363_/B _3125_/A vdd gnd MUX2X1
XFILL_1__3171_ vdd gnd FILL
X_3957_ _3957_/D _3961_/CLK _3957_/Q vdd gnd DFFPOSX1
X_2006_ _2177_/A _2006_/B _4152_/D vdd gnd NOR2X1
X_2839_ _3977_/Q _2843_/B _2840_/C vdd gnd NAND2X1
X_3888_ _3888_/D _3997_/CLK _3888_/Q vdd gnd DFFPOSX1
X_2908_ _2928_/A _2908_/B _2908_/C _2909_/A vdd gnd OAI21X1
XFILL_1__2053_ vdd gnd FILL
XFILL_1__3369_ vdd gnd FILL
XFILL_0__2562_ vdd gnd FILL
XFILL_0__2700_ vdd gnd FILL
XFILL_0__3680_ vdd gnd FILL
XFILL_0__2493_ vdd gnd FILL
X_3811_ _3897_/Y _3811_/Y vdd gnd INVX1
XFILL_0__3114_ vdd gnd FILL
X_3742_ _3742_/A _3742_/B _3750_/S _4184_/D vdd gnd MUX2X1
X_2624_ _3733_/A _3733_/B _3350_/B _3386_/B vdd gnd MUX2X1
X_3673_ _3887_/Q _3676_/C vdd gnd INVX1
XFILL_1__2740_ vdd gnd FILL
X_2555_ _2555_/A _2580_/B _2555_/C _4093_/D vdd gnd AOI21X1
X_2486_ _3851_/Q _3081_/A vdd gnd INVX1
X_3038_ _3038_/A _3038_/B _3038_/C _3876_/D vdd gnd AOI21X1
X_3107_ _3107_/A _3841_/Q _3839_/Q _3108_/B vdd gnd AOI21X1
X_4087_ _4087_/D _2244_/A _4087_/Q vdd gnd DFFPOSX1
X_4156_ _4156_/D _4173_/CLK _4156_/Q vdd gnd DFFPOSX1
XFILL_0_CLKBUF1_insert127 vdd gnd FILL
XFILL_0_CLKBUF1_insert149 vdd gnd FILL
XFILL_1__3154_ vdd gnd FILL
XFILL_0_CLKBUF1_insert138 vdd gnd FILL
XFILL_1__2938_ vdd gnd FILL
X_2340_ _2556_/B _3809_/A vdd gnd INVX2
XFILL_0__3801_ vdd gnd FILL
X_2271_ _4178_/Q _3237_/A vdd gnd INVX1
XFILL_0__3732_ vdd gnd FILL
XFILL_0__1993_ vdd gnd FILL
XFILL_0__2614_ vdd gnd FILL
XFILL_0__3594_ vdd gnd FILL
X_4010_ _4010_/D _4034_/CLK _4010_/Q vdd gnd DFFPOSX1
XFILL_0__2476_ vdd gnd FILL
X_1986_ _2645_/A _1986_/B _1986_/C _1987_/A vdd gnd OAI21X1
X_2607_ _2607_/A _2607_/B _2609_/A vdd gnd NAND2X1
XFILL_0__3028_ vdd gnd FILL
X_3725_ _3812_/B _3726_/B vdd gnd INVX1
X_3656_ _3658_/C _3662_/B _3656_/C _3662_/D _3923_/D vdd gnd OAI22X1
X_3587_ _3622_/A _3587_/B _3587_/C _4000_/D vdd gnd AOI21X1
X_2538_ _4072_/Q _2589_/A _2538_/C _2594_/A _2539_/A vdd gnd OAI22X1
X_2469_ _3054_/B _2469_/B _2469_/C _2470_/B vdd gnd OAI21X1
X_4139_ _4139_/D _4139_/CLK _4139_/Q vdd gnd DFFPOSX1
XFILL_1__3206_ vdd gnd FILL
XFILL_0__2330_ vdd gnd FILL
XFILL_0__2192_ vdd gnd FILL
X_3441_ _4069_/Q _3444_/B vdd gnd INVX1
X_3510_ _3526_/S _3510_/B _3511_/B vdd gnd NAND2X1
X_2254_ _2254_/A _2254_/B _2581_/C vdd gnd NAND2X1
X_2323_ _4083_/Q _2331_/A _2493_/A vdd gnd NOR2X1
X_3372_ _3802_/B _3372_/B _3373_/B _3373_/C vdd gnd AOI21X1
XFILL_0__3715_ vdd gnd FILL
XFILL_0__1976_ vdd gnd FILL
XFILL_0__2528_ vdd gnd FILL
XFILL_1__2370_ vdd gnd FILL
X_2185_ _2185_/A _4111_/Q _2185_/S _2186_/B vdd gnd MUX2X1
X_1969_ _1969_/A _4161_/Q _2176_/S _1970_/B vdd gnd MUX2X1
X_3639_ _3957_/Q _3642_/C vdd gnd INVX1
X_3708_ _3708_/A _3708_/B _3712_/A vdd gnd NAND2X1
XFILL_1__3686_ vdd gnd FILL
XFILL_1__2568_ vdd gnd FILL
X_3990_ _3990_/D _4027_/CLK _3990_/Q vdd gnd DFFPOSX1
XFILL_0__3431_ vdd gnd FILL
X_2872_ _2880_/A _2872_/B _2872_/C _2873_/A vdd gnd OAI21X1
XFILL_0__2244_ vdd gnd FILL
XFILL_0__2313_ vdd gnd FILL
X_2941_ _2941_/A _4197_/R _3927_/D vdd gnd AND2X2
XFILL_0__3293_ vdd gnd FILL
XFILL_1_BUFX2_insert184 vdd gnd FILL
X_3424_ _3426_/B _3424_/B _3430_/S _4088_/D vdd gnd MUX2X1
X_2306_ _3347_/A _3352_/A _3344_/A _2312_/B vdd gnd NAND3X1
X_3355_ _3959_/Q _3750_/A vdd gnd INVX1
XFILL_1__3471_ vdd gnd FILL
X_3286_ _3286_/A _3729_/A _3287_/C vdd gnd NAND2X1
X_2237_ _4057_/Q _3862_/Q _2652_/S _2238_/B vdd gnd MUX2X1
X_2099_ _3718_/A _4018_/Q _2100_/A vdd gnd NAND2X1
X_2168_ _2655_/A _2168_/B _4116_/D vdd gnd NOR2X1
XFILL_0__3629_ vdd gnd FILL
XFILL_1__3669_ vdd gnd FILL
XFILL_0_BUFX2_insert125 vdd gnd FILL
XFILL_0_BUFX2_insert103 vdd gnd FILL
XFILL_0__2931_ vdd gnd FILL
XFILL_0__2793_ vdd gnd FILL
X_3071_ _3071_/A _3152_/A _3071_/C _3859_/D vdd gnd AOI21X1
X_3140_ _3140_/A _3310_/B _3318_/C vdd gnd NAND2X1
X_3973_ _3973_/D _3985_/CLK _3973_/Q vdd gnd DFFPOSX1
XFILL_0__3345_ vdd gnd FILL
X_2022_ _2157_/A _2022_/B _2022_/C _2023_/A vdd gnd OAI21X1
X_2855_ _3969_/Q _2864_/A _2856_/C vdd gnd NAND2X1
X_2786_ _4001_/Q _3999_/Q _3019_/A _2788_/B vdd gnd MUX2X1
X_2924_ _2928_/A _2924_/B _2924_/C _2925_/A vdd gnd OAI21X1
XFILL_0__2227_ vdd gnd FILL
X_3338_ _3338_/A _4139_/D vdd gnd INVX1
X_3407_ _4106_/Q _3410_/B vdd gnd INVX1
XFILL132750x39750 vdd gnd FILL
XFILL_1__2405_ vdd gnd FILL
X_3269_ _4164_/Q _3272_/B _3364_/A _3270_/D vdd gnd OAI21X1
XFILL_1__3523_ vdd gnd FILL
XFILL132750x82950 vdd gnd FILL
XFILL_1__2198_ vdd gnd FILL
XFILL_0__3130_ vdd gnd FILL
XFILL_0__3061_ vdd gnd FILL
X_2640_ _4097_/Q _3222_/A _2642_/A vdd gnd NOR2X1
X_2571_ _2571_/A _2571_/B _2574_/C vdd gnd NAND2X1
XFILL_0__2914_ vdd gnd FILL
XFILL_0__2845_ vdd gnd FILL
X_3054_ _3071_/C _3054_/B _3866_/D vdd gnd NOR2X1
X_4172_ _4172_/D _4172_/CLK _4172_/Q vdd gnd DFFPOSX1
X_3123_ _3822_/Q _3737_/A vdd gnd INVX1
X_2005_ _2005_/A _4152_/Q _2131_/S _2006_/B vdd gnd MUX2X1
X_3956_ _3956_/D _3977_/CLK _3956_/Q vdd gnd DFFPOSX1
X_2907_ _3944_/Q _3027_/A _2908_/C vdd gnd NAND2X1
XFILL_0__3328_ vdd gnd FILL
XFILL_0__3259_ vdd gnd FILL
XFILL132750x14550 vdd gnd FILL
X_2838_ _3975_/Q _3973_/Q _2878_/S _2840_/B vdd gnd MUX2X1
X_2769_ _2769_/A _4013_/Q _2769_/C _4013_/D vdd gnd AOI21X1
X_3887_ _3887_/D _3961_/CLK _3887_/Q vdd gnd DFFPOSX1
XFILL132150x10950 vdd gnd FILL
XFILL_1__2885_ vdd gnd FILL
XCLKBUF1_insert190 _3881_/Q CLKBUF1_insert190/Y vdd gnd CLKBUF1
XFILL_1__3506_ vdd gnd FILL
XFILL_1__3299_ vdd gnd FILL
XFILL_0__2561_ vdd gnd FILL
XFILL_0__2630_ vdd gnd FILL
X_3810_ _3810_/A _3810_/B _3864_/D vdd gnd NAND2X1
X_3741_ _3741_/A _3741_/B _3750_/S _4186_/D vdd gnd MUX2X1
X_2554_ _2581_/B _2580_/B _3901_/A _2555_/C vdd gnd OAI21X1
XFILL_0__3044_ vdd gnd FILL
X_2623_ _3830_/Q _3733_/A vdd gnd INVX1
X_3672_ _3674_/C _3672_/B _3672_/C _3672_/D _3891_/D vdd gnd OAI22X1
X_2485_ _2563_/B _2598_/A _2495_/B vdd gnd NOR2X1
XFILL_0__2828_ vdd gnd FILL
X_4155_ _4155_/D _4157_/CLK _4155_/Q vdd gnd DFFPOSX1
X_3037_ _4050_/Q _3103_/B _3876_/Q _3038_/B vdd gnd OAI21X1
X_3106_ _3106_/A _3117_/A _3113_/B vdd gnd NOR2X1
XFILL_0__2759_ vdd gnd FILL
X_4086_ _4086_/D _4094_/CLK _4086_/Q vdd gnd DFFPOSX1
X_3939_ _3947_/S vdd _3939_/D _4121_/D _3939_/Q vdd gnd DFFSR
XFILL_1__2035_ vdd gnd FILL
X_2270_ _3466_/C _2270_/B _2270_/C _3525_/B vdd gnd AOI21X1
XFILL_0__3662_ vdd gnd FILL
XFILL_0_BUFX2_insert19 vdd gnd FILL
XFILL_0__2544_ vdd gnd FILL
XFILL_0_CLKBUF1_insert63 vdd gnd FILL
X_3724_ _3810_/B _3724_/B _3812_/B vdd gnd AND2X2
X_1985_ _4063_/Q _3879_/Q _3221_/D _1986_/B vdd gnd MUX2X1
X_2537_ _4074_/Q _2586_/A _2537_/C _2539_/B vdd gnd OAI21X1
X_2606_ _2606_/A _2607_/B _2606_/C _4058_/D vdd gnd AOI21X1
X_3655_ _3923_/Q _3658_/C vdd gnd INVX1
X_3586_ _4000_/Q _3622_/A _3587_/C vdd gnd NOR2X1
XFILL_1__2722_ vdd gnd FILL
X_2468_ _2469_/B _3866_/Q _2468_/C _2469_/C vdd gnd AOI21X1
X_2399_ _2399_/A _3485_/A _3525_/B _3488_/C vdd gnd MUX2X1
X_4138_ _4138_/D _4148_/CLK _4138_/Q vdd gnd DFFPOSX1
XFILL132450x36150 vdd gnd FILL
X_4069_ _4069_/D _4100_/CLK _4069_/Q vdd gnd DFFPOSX1
XFILL_1__3136_ vdd gnd FILL
XFILL_1__2018_ vdd gnd FILL
XFILL_0__2260_ vdd gnd FILL
XFILL_0__2191_ vdd gnd FILL
X_3371_ _4127_/Q _3381_/A vdd gnd INVX1
X_3440_ _3442_/B _3440_/B _3453_/S _4071_/D vdd gnd MUX2X1
X_2322_ _4081_/Q _2331_/A vdd gnd INVX1
X_2253_ _4081_/Q _4083_/Q _4079_/Q _2254_/A vdd gnd OAI21X1
XFILL_0__3645_ vdd gnd FILL
X_2184_ _2227_/C _2184_/B _2184_/C _2185_/A vdd gnd OAI21X1
XFILL_0__2458_ vdd gnd FILL
XFILL_0__3576_ vdd gnd FILL
X_1968_ _1968_/A _3221_/D _1968_/C _1969_/A vdd gnd OAI21X1
X_3707_ _4192_/Q _4061_/Q _3711_/B _3708_/B vdd gnd OAI21X1
X_3638_ _3640_/C _3672_/B _3638_/C _3680_/D _3961_/D vdd gnd OAI22X1
X_3569_ _3620_/A _4010_/Q _3569_/C _3571_/B vdd gnd OAI21X1
XFILL_1__2705_ vdd gnd FILL
XFILL_1__2498_ vdd gnd FILL
X_2940_ _2988_/A _2940_/B _2940_/C _2941_/A vdd gnd OAI21X1
XFILL_0__3361_ vdd gnd FILL
XFILL_0__3292_ vdd gnd FILL
X_2871_ _3960_/Q _2880_/A _2872_/C vdd gnd NAND2X1
XFILL_0__2174_ vdd gnd FILL
X_3354_ _3354_/A _4135_/D vdd gnd INVX1
X_3423_ _4088_/Q _3426_/B vdd gnd INVX1
X_2305_ _4139_/Q _3344_/A vdd gnd INVX1
X_3285_ _3838_/Q _3729_/A vdd gnd INVX1
XFILL_0__1958_ vdd gnd FILL
X_2167_ _2167_/A _4116_/Q _2185_/S _2168_/B vdd gnd MUX2X1
X_2236_ _2236_/A _2236_/B _2653_/A _2238_/C vdd gnd OAI21X1
XFILL_1__2352_ vdd gnd FILL
XFILL_0__3559_ vdd gnd FILL
X_2098_ _3743_/B _2179_/B _2101_/B vdd gnd NOR2X1
XFILL_0_BUFX2_insert115 vdd gnd FILL
XFILL_0__2861_ vdd gnd FILL
X_3070_ _3070_/A _3070_/B _3071_/A vdd gnd AND2X2
X_2021_ _4071_/Q _3895_/Q _2228_/S _2022_/B vdd gnd MUX2X1
X_2923_ _3936_/Q _2928_/A _2924_/C vdd gnd NAND2X1
XFILL_0__3275_ vdd gnd FILL
X_3972_ _4180_/R vdd _3972_/D _4166_/CLK _3972_/Q vdd gnd DFFSR
XFILL_0__3413_ vdd gnd FILL
X_2854_ _3967_/Q _3965_/Q _2878_/S _2856_/B vdd gnd MUX2X1
X_2785_ _2785_/A _3136_/B _4005_/D vdd gnd AND2X2
XFILL_0__2157_ vdd gnd FILL
XFILL_0__2088_ vdd gnd FILL
X_3337_ _3337_/A _3337_/B _3337_/C _3338_/A vdd gnd NAND3X1
X_3406_ _3408_/B _3406_/B _3448_/S _4108_/D vdd gnd MUX2X1
XFILL_1__1921_ vdd gnd FILL
XFILL_1__2335_ vdd gnd FILL
X_3268_ _4162_/Q _3270_/A vdd gnd INVX1
X_3199_ _4150_/Q _3363_/B _3199_/C _3792_/A vdd gnd OAI21X1
X_2219_ _4119_/Q _3931_/Q _2652_/S _2220_/B vdd gnd MUX2X1
XFILL_1__3453_ vdd gnd FILL
X_2570_ _2573_/A _2573_/B _2571_/B vdd gnd NOR2X1
XFILL_0__2011_ vdd gnd FILL
X_4171_ _4171_/D _4183_/CLK _4171_/Q vdd gnd DFFPOSX1
X_3122_ _3831_/Q _3344_/C _3126_/B vdd gnd NAND2X1
XFILL_0__2913_ vdd gnd FILL
X_3053_ _3053_/A _3053_/B _3053_/C _3868_/D vdd gnd AOI21X1
XFILL_0__2775_ vdd gnd FILL
X_2004_ _2175_/A _2004_/B _2004_/C _2005_/A vdd gnd OAI21X1
X_3886_ _3886_/D _4050_/CLK _3886_/Q vdd gnd DFFPOSX1
X_2906_ _3942_/Q _3940_/Q _3006_/S _2908_/B vdd gnd MUX2X1
XFILL_0__3327_ vdd gnd FILL
X_3955_ _4201_/R vdd _3955_/D _4182_/CLK _3955_/Q vdd gnd DFFSR
XFILL_0__2209_ vdd gnd FILL
X_2837_ _2837_/A _2885_/B _3979_/D vdd gnd AND2X2
X_2768_ _4013_/Q _2950_/S _4197_/R _2769_/C vdd gnd OAI21X1
X_2699_ _2705_/B _2699_/B _2699_/C _4032_/D vdd gnd AOI21X1
XFILL_0__3189_ vdd gnd FILL
XCLKBUF1_insert191 _3881_/Q CLKBUF1_insert191/Y vdd gnd CLKBUF1
XFILL_0__2491_ vdd gnd FILL
XFILL_0__3112_ vdd gnd FILL
X_3740_ _3740_/A _3740_/B _3750_/S _4195_/D vdd gnd MUX2X1
X_2553_ _2608_/A _2581_/B vdd gnd INVX1
X_2622_ _3391_/S _2622_/Y vdd gnd INVX8
X_3671_ _3891_/Q _3674_/C vdd gnd INVX1
X_4085_ _4085_/D _4089_/CLK _4085_/Q vdd gnd DFFPOSX1
X_3105_ _3105_/A _3121_/A _3841_/D vdd gnd NOR2X1
X_2484_ _3874_/Q _2516_/B _2685_/S _2512_/A _2598_/A vdd gnd AOI22X1
X_4154_ _4154_/D _3806_/A _4154_/Q vdd gnd DFFPOSX1
X_3036_ _3036_/A _3036_/B _3038_/C _3878_/D vdd gnd AOI21X1
XFILL_0__2689_ vdd gnd FILL
XFILL_0_CLKBUF1_insert129 vdd gnd FILL
X_3938_ _3938_/D _4003_/CLK _3938_/Q vdd gnd DFFPOSX1
XFILL_1__3083_ vdd gnd FILL
X_3869_ _4194_/Q _3926_/B vdd gnd INVX1
XFILL_1__2867_ vdd gnd FILL
XFILL_0__2612_ vdd gnd FILL
XFILL_0__3730_ vdd gnd FILL
XFILL_0__1991_ vdd gnd FILL
XFILL_0__2474_ vdd gnd FILL
XFILL_0__3592_ vdd gnd FILL
XFILL_0__3026_ vdd gnd FILL
X_3723_ _3723_/A _3723_/B _3771_/A _3846_/D vdd gnd AOI21X1
X_3654_ _3656_/C _3662_/B _3654_/C _3662_/D _3928_/D vdd gnd OAI22X1
X_1984_ _1984_/A _1984_/B _2645_/A _1986_/C vdd gnd OAI21X1
X_2536_ _4072_/Q _2589_/A _2537_/C vdd gnd NAND2X1
X_2605_ _4058_/Q _2607_/B _2758_/A _2606_/C vdd gnd OAI21X1
X_2467_ _2579_/A _2579_/B _2470_/A vdd gnd NOR2X1
XFILL_1__3770_ vdd gnd FILL
X_3585_ _3620_/A _4002_/Q _3585_/C _3587_/B vdd gnd OAI21X1
X_4068_ _4068_/D _4089_/CLK _4068_/Q vdd gnd DFFPOSX1
X_4137_ _4137_/D _4139_/CLK _4137_/Q vdd gnd DFFPOSX1
X_2398_ _4051_/Q _3485_/A vdd gnd INVX1
XFILL_1__2652_ vdd gnd FILL
X_3019_ _3019_/A _3019_/B _3019_/C _3021_/B vdd gnd OAI21X1
XFILL_1__3066_ vdd gnd FILL
XFILL131850x82950 vdd gnd FILL
X_2321_ _3868_/Q _2546_/B _2685_/S _2547_/A _2604_/A vdd gnd AOI22X1
X_3370_ _3370_/A _3370_/B _3370_/C _3370_/D _4129_/D vdd gnd AOI22X1
XFILL_0__1974_ vdd gnd FILL
X_2252_ _2252_/A _2254_/B vdd gnd INVX1
XFILL_0__3644_ vdd gnd FILL
X_2183_ _4110_/Q _3970_/Q _2652_/S _2184_/B vdd gnd MUX2X1
XFILL_0__3713_ vdd gnd FILL
XFILL_0__2526_ vdd gnd FILL
XFILL_0__2388_ vdd gnd FILL
X_3637_ _3961_/Q _3640_/C vdd gnd INVX1
X_1967_ _4048_/Q _1975_/B _3871_/Q _1968_/A vdd gnd OAI21X1
X_3706_ _3706_/A _3706_/B _3711_/B vdd gnd NAND2X1
X_2519_ _4060_/Q _2604_/A _2519_/C _2524_/A vdd gnd OAI21X1
X_3499_ _3625_/A _3730_/B _3505_/C vdd gnd NAND2X1
X_3568_ _3620_/A _3745_/B _3569_/C vdd gnd NAND2X1
XFILL_1__3118_ vdd gnd FILL
X_2870_ _3958_/Q _3956_/Q _2878_/S _2872_/B vdd gnd MUX2X1
XFILL_1_BUFX2_insert175 vdd gnd FILL
XFILL_0__2311_ vdd gnd FILL
XFILL_0__2242_ vdd gnd FILL
X_2304_ _4137_/Q _3352_/A vdd gnd INVX1
X_3353_ _3353_/A _3353_/B _3353_/C _3354_/A vdd gnd NAND3X1
X_3284_ _3385_/B _3284_/B _3284_/C _4158_/D vdd gnd AOI21X1
X_3422_ _3424_/B _3422_/B _3430_/S _4090_/D vdd gnd MUX2X1
X_2166_ _2227_/C _2166_/B _2166_/C _2167_/A vdd gnd OAI21X1
X_2097_ _4132_/Q _3743_/B vdd gnd INVX1
XFILL_0__3627_ vdd gnd FILL
X_2235_ _2235_/A _2650_/B _2236_/A vdd gnd NOR2X1
XFILL_0__2509_ vdd gnd FILL
X_2999_ _3896_/Q _3008_/A _3000_/C vdd gnd NAND2X1
XFILL_1__2282_ vdd gnd FILL
XFILL_1__3805_ vdd gnd FILL
XFILL_1__3598_ vdd gnd FILL
XFILL_0_BUFX2_insert116 vdd gnd FILL
XFILL_0_BUFX2_insert105 vdd gnd FILL
XFILL_0__2791_ vdd gnd FILL
X_2020_ _2020_/A _2020_/B _2175_/A _2022_/C vdd gnd OAI21X1
X_3971_ _3971_/D _3985_/CLK _3971_/Q vdd gnd DFFPOSX1
X_2853_ _2853_/A _2885_/B _3971_/D vdd gnd AND2X2
X_2922_ _3934_/Q _3932_/Q _3006_/S _2924_/B vdd gnd MUX2X1
XFILL_0__3343_ vdd gnd FILL
XFILL_0__2225_ vdd gnd FILL
X_2784_ _2796_/A _2784_/B _2784_/C _2785_/A vdd gnd OAI21X1
XFILL_0__2156_ vdd gnd FILL
XFILL_0__2989_ vdd gnd FILL
X_3336_ _3336_/A _3352_/B _3358_/C _3337_/B vdd gnd NAND3X1
X_3267_ _3267_/A _3370_/B _3267_/C _3267_/D _4164_/D vdd gnd AOI22X1
X_3405_ _4108_/Q _3408_/B vdd gnd INVX1
XFILL_1__3383_ vdd gnd FILL
X_3198_ _3798_/A _3752_/A _3199_/C vdd gnd NAND2X1
X_2149_ _2149_/A _4120_/Q _2158_/S _2150_/B vdd gnd MUX2X1
X_2218_ _2218_/A _2218_/B _2227_/C _2220_/C vdd gnd OAI21X1
XFILL131550x36150 vdd gnd FILL
XFILL_1_CLKBUF1_insert171 vdd gnd FILL
X_3121_ _3121_/A _3121_/B _3833_/D vdd gnd NOR2X1
XFILL_0__2843_ vdd gnd FILL
X_4170_ _4170_/D _4172_/CLK _4170_/Q vdd gnd DFFPOSX1
X_3052_ _3868_/Q _3053_/A _3136_/B _3053_/C vdd gnd OAI21X1
X_2003_ _4067_/Q _3887_/Q _2165_/S _2004_/B vdd gnd MUX2X1
X_3954_ _3954_/D _3977_/CLK _3954_/Q vdd gnd DFFPOSX1
X_2836_ _2843_/B _2836_/B _2836_/C _2837_/A vdd gnd OAI21X1
X_2905_ _3006_/S _3019_/B _2905_/Y vdd gnd NOR2X1
XFILL_0__3257_ vdd gnd FILL
X_3885_ _3885_/D _4101_/CLK _3885_/Q vdd gnd DFFPOSX1
XFILL_0__2139_ vdd gnd FILL
X_2767_ _2767_/A _4014_/D vdd gnd INVX1
X_2698_ _2950_/S _4031_/Q _3947_/S _2699_/C vdd gnd OAI21X1
X_3319_ _4145_/Q _3321_/A vdd gnd INVX1
XFILL132450x64950 vdd gnd FILL
XCLKBUF1_insert170 CLKBUF1_insert188/Y _4106_/CLK vdd gnd CLKBUF1
XFILL_1__3435_ vdd gnd FILL
XFILL_1__2317_ vdd gnd FILL
XFILL_0__3042_ vdd gnd FILL
X_3670_ _3672_/C _3680_/B _3670_/C _3683_/D _3895_/D vdd gnd OAI22X1
X_2552_ _2552_/A _2552_/B _2555_/A vdd gnd NAND2X1
X_2621_ _4052_/Q _3323_/C _2626_/B vdd gnd NAND2X1
X_2483_ _2546_/B _3359_/D _2512_/A vdd gnd NOR2X1
X_3104_ _3104_/A _3117_/A _3105_/A vdd gnd NAND2X1
X_3035_ _3835_/Q _3035_/B _3036_/A vdd gnd NAND2X1
XFILL_0__2757_ vdd gnd FILL
XFILL_0__2826_ vdd gnd FILL
X_4153_ _4153_/D _4166_/CLK _4153_/Q vdd gnd DFFPOSX1
X_4084_ _4084_/D _4084_/CLK _4084_/Q vdd gnd DFFPOSX1
X_3937_ _3937_/D _3961_/CLK _3937_/Q vdd gnd DFFPOSX1
XFILL_1__3220_ vdd gnd FILL
X_2819_ _3987_/Q _2827_/B _2820_/C vdd gnd NAND2X1
X_3868_ _3868_/D _4139_/CLK _3868_/Q vdd gnd DFFPOSX1
X_3799_ _3799_/A _3799_/B _3799_/C _3800_/A vdd gnd NAND3X1
XFILL_1__2797_ vdd gnd FILL
XFILL_1__3418_ vdd gnd FILL
XFILL_0__2542_ vdd gnd FILL
XFILL_0__3660_ vdd gnd FILL
XFILL_0_CLKBUF1_insert65 vdd gnd FILL
XFILL_0__2473_ vdd gnd FILL
X_2604_ _2604_/A _2607_/B _2604_/C _4060_/D vdd gnd AOI21X1
X_3653_ _3928_/Q _3656_/C vdd gnd INVX1
X_3722_ _3722_/A _3846_/Q _3772_/Y _3723_/B vdd gnd AOI21X1
X_1983_ _1983_/A _2172_/B _1984_/A vdd gnd NOR2X1
X_2535_ _2535_/A _2607_/A _2535_/C _2540_/B vdd gnd AOI21X1
X_2466_ _2689_/A _2466_/B _2466_/C _2479_/B vdd gnd AOI21X1
X_3584_ _3617_/A _3749_/B _3585_/C vdd gnd NAND2X1
X_3018_ _3025_/S _3022_/A _3018_/C _3019_/C vdd gnd OAI21X1
X_2397_ _3478_/C _2397_/B _2401_/A vdd gnd NAND2X1
X_4067_ _4067_/D _4106_/CLK _4067_/Q vdd gnd DFFPOSX1
X_4136_ _4136_/D _4146_/CLK _4136_/Q vdd gnd DFFPOSX1
XFILL132150x86550 vdd gnd FILL
X_2251_ _2562_/A _2252_/A _2500_/A _2583_/B vdd gnd OAI21X1
X_2320_ _2546_/B _3344_/A _2547_/A vdd gnd NOR2X1
XFILL_0__3574_ vdd gnd FILL
X_2182_ _2182_/A _2182_/B _2182_/C _2184_/C vdd gnd OAI21X1
XFILL_0__2456_ vdd gnd FILL
X_1966_ _3901_/Y _3897_/A _3926_/Y _1966_/Y vdd gnd OAI21X1
XFILL_0__3008_ vdd gnd FILL
X_3567_ _3595_/A _3567_/B _3567_/C _4010_/D vdd gnd AOI21X1
X_3636_ _3638_/C _3680_/B _3636_/C _3680_/D _3966_/D vdd gnd OAI22X1
X_3705_ _3924_/Q _3715_/B _3706_/B vdd gnd NAND2X1
XFILL_1__2634_ vdd gnd FILL
X_2518_ _4058_/Q _2518_/B _2518_/C _2519_/C vdd gnd NAND3X1
X_2449_ _3917_/A _3449_/C _2458_/C vdd gnd NAND2X1
XFILL_1__3752_ vdd gnd FILL
X_3498_ _3504_/B _3498_/B _3626_/B _4047_/D vdd gnd MUX2X1
XFILL132150x61350 vdd gnd FILL
X_4119_ _4119_/D _4119_/CLK _4119_/Q vdd gnd DFFPOSX1
XFILL_1__3048_ vdd gnd FILL
XFILL_0__3290_ vdd gnd FILL
XFILL_0__2310_ vdd gnd FILL
XFILL_0__2172_ vdd gnd FILL
X_3421_ _4090_/Q _3424_/B vdd gnd INVX1
X_3352_ _3352_/A _3352_/B _3358_/C _3353_/B vdd gnd NAND3X1
X_2303_ _4135_/Q _3347_/A vdd gnd INVX1
X_3283_ _4158_/Q _3385_/B _3284_/C vdd gnd NOR2X1
XFILL_0__1956_ vdd gnd FILL
X_2234_ _2649_/A _4051_/Q _2235_/A vdd gnd NAND2X1
XFILL_0__2508_ vdd gnd FILL
XFILL_0__3488_ vdd gnd FILL
X_2096_ _2186_/A _2096_/B _4132_/D vdd gnd NOR2X1
X_2165_ _4106_/Q _3961_/Q _2165_/S _2166_/B vdd gnd MUX2X1
XFILL_0__3557_ vdd gnd FILL
X_2998_ _3894_/Q _3892_/Q _3006_/S _3000_/B vdd gnd MUX2X1
X_1949_ _4163_/Q _1949_/B _3846_/Q _3699_/B vdd gnd OAI21X1
X_3619_ _3620_/A _3734_/B _3620_/C vdd gnd NAND2X1
XFILL_1__1996_ vdd gnd FILL
XFILL_1__3735_ vdd gnd FILL
XFILL_0__2790_ vdd gnd FILL
XFILL_0__3411_ vdd gnd FILL
X_3970_ _3970_/D _4071_/CLK _3970_/Q vdd gnd DFFPOSX1
X_2852_ _2864_/A _2852_/B _2852_/C _2853_/A vdd gnd OAI21X1
X_2783_ _4005_/Q _2796_/A _2784_/C vdd gnd NAND2X1
X_2921_ _2921_/A _3976_/R _3938_/D vdd gnd AND2X2
XFILL_0__3273_ vdd gnd FILL
X_3404_ _3406_/B _3404_/B _3448_/S _4110_/D vdd gnd MUX2X1
XFILL_0__2086_ vdd gnd FILL
XFILL_0__2988_ vdd gnd FILL
X_3335_ _3335_/A _3802_/B _3337_/A vdd gnd NAND2X1
X_3266_ _4166_/Q _3272_/B _3364_/A _3267_/D vdd gnd OAI21X1
X_3197_ _3951_/Q _3752_/A vdd gnd INVX1
X_2217_ _2217_/A _2650_/B _2218_/A vdd gnd NOR2X1
XFILL_1__2264_ vdd gnd FILL
X_2148_ _2155_/C _2148_/B _2148_/C _2149_/A vdd gnd OAI21X1
XFILL_0__3609_ vdd gnd FILL
X_2079_ _4136_/Q _3745_/B vdd gnd INVX1
XFILL_0__2911_ vdd gnd FILL
X_3120_ _3833_/Q _3120_/B _3120_/C _3121_/B vdd gnd OAI21X1
X_3051_ _3825_/Q _3843_/Q _3841_/Q _3053_/B vdd gnd MUX2X1
XFILL_0__2773_ vdd gnd FILL
XFILL_0__3325_ vdd gnd FILL
X_3953_ _3953_/D _4100_/CLK _3953_/Q vdd gnd DFFPOSX1
X_2002_ _2002_/A _2002_/B _2175_/A _2004_/C vdd gnd OAI21X1
X_2904_ _2904_/A _3009_/B _3946_/D vdd gnd AND2X2
X_3884_ _3884_/D _4052_/CLK _3884_/Q vdd gnd DFFPOSX1
X_2835_ _3979_/Q _2843_/B _2836_/C vdd gnd NAND2X1
X_2766_ _2766_/A _2766_/B _2766_/C _2767_/A vdd gnd NAND3X1
XFILL_0__2207_ vdd gnd FILL
XFILL_0__3187_ vdd gnd FILL
X_3318_ _3318_/A _3388_/A _3318_/C _3318_/D _4147_/D vdd gnd AOI22X1
XFILL_1__2951_ vdd gnd FILL
X_2697_ _2707_/A _3022_/B _2699_/B vdd gnd NOR2X1
XCLKBUF1_insert160 CLKBUF1_insert188/Y _4193_/CLK vdd gnd CLKBUF1
XFILL_0__2069_ vdd gnd FILL
X_3249_ _3249_/A _3478_/C _3272_/B vdd gnd NAND2X1
XCLKBUF1_insert171 CLKBUF1_insert191/Y _4199_/CLK vdd gnd CLKBUF1
XFILL_1__2247_ vdd gnd FILL
XFILL_1__3365_ vdd gnd FILL
XFILL_0__3110_ vdd gnd FILL
XFILL_0__3041_ vdd gnd FILL
X_2620_ _3344_/C _2620_/B _3121_/A _4054_/D vdd gnd AOI21X1
X_2482_ _2600_/A _2482_/B _2496_/B vdd gnd OR2X2
X_2551_ _2551_/A _2551_/B _2551_/C _2552_/B vdd gnd NAND3X1
X_3034_ _4050_/Q _3103_/B _3878_/Q _3036_/B vdd gnd OAI21X1
X_3103_ _4050_/Q _3103_/B _3103_/C _3104_/A vdd gnd OAI21X1
XFILL_0__2825_ vdd gnd FILL
X_4083_ _4083_/D _4101_/CLK _4083_/Q vdd gnd DFFPOSX1
XFILL_0__2687_ vdd gnd FILL
X_4152_ _4152_/D _4157_/CLK _4152_/Q vdd gnd DFFPOSX1
X_3936_ _3936_/D _4184_/CLK _3936_/Q vdd gnd DFFPOSX1
XFILL_0__3308_ vdd gnd FILL
XFILL_1__2101_ vdd gnd FILL
XFILL_0__3239_ vdd gnd FILL
X_2749_ _4022_/Q _3022_/B _3022_/C vdd gnd NAND2X1
X_2818_ _3985_/Q _3983_/Q _2994_/S _2820_/B vdd gnd MUX2X1
X_3798_ _3798_/A _3798_/B _3798_/C _3799_/B vdd gnd OAI21X1
X_3867_ _3867_/D _4114_/CLK _3867_/Q vdd gnd DFFPOSX1
XFILL_0__2610_ vdd gnd FILL
XFILL_0__3590_ vdd gnd FILL
X_1982_ _3718_/A _3988_/Q _1983_/A vdd gnd NAND2X1
X_2534_ _2607_/A _2535_/A _4092_/Q _2535_/C vdd gnd OAI21X1
XFILL_0__3024_ vdd gnd FILL
X_2603_ _4060_/Q _2607_/B _3901_/A _2604_/C vdd gnd OAI21X1
X_3652_ _3654_/C _3662_/B _3652_/C _3662_/D _3933_/D vdd gnd OAI22X1
X_3721_ _3721_/A _3721_/B _3723_/A vdd gnd NAND2X1
X_3583_ _3611_/A _3583_/B _3583_/C _4002_/D vdd gnd AOI21X1
XFILL_0__2808_ vdd gnd FILL
X_4135_ _4135_/D _4135_/CLK _4135_/Q vdd gnd DFFPOSX1
X_2465_ _3054_/B _2466_/B _2468_/C _2466_/C vdd gnd OAI21X1
X_2396_ _3921_/A _3449_/C _3460_/B vdd gnd NAND2X1
XFILL_0__3926_ vdd gnd FILL
X_4066_ _4066_/D _4089_/CLK _4066_/Q vdd gnd DFFPOSX1
X_3017_ _3886_/Q _3019_/A _3018_/C vdd gnd NAND2X1
XFILL_1__2581_ vdd gnd FILL
XFILL_1__3202_ vdd gnd FILL
XFILL_0__3788_ vdd gnd FILL
X_3919_ _3919_/D _4071_/CLK _3919_/Q vdd gnd DFFPOSX1
XFILL_1__2779_ vdd gnd FILL
X_2250_ _2579_/A _2250_/B _2500_/A vdd gnd NAND2X1
XFILL_0__3642_ vdd gnd FILL
XFILL_0__3711_ vdd gnd FILL
XFILL_0__1972_ vdd gnd FILL
XFILL_0__2524_ vdd gnd FILL
X_2181_ _2181_/A _2181_/B _2182_/A vdd gnd NOR2X1
XFILL_0__2386_ vdd gnd FILL
X_1965_ _1965_/A _1965_/B _1968_/C vdd gnd NAND2X1
X_3704_ _4171_/Q _3704_/B _3706_/A vdd gnd NAND2X1
X_2517_ _2517_/A _2685_/S _2518_/C vdd gnd NAND2X1
XBUFX2_insert180 _3726_/Y _3755_/S vdd gnd BUFX2
X_3566_ _4010_/Q _3599_/A _3567_/C vdd gnd NOR2X1
X_3497_ _3625_/A _3497_/B _3497_/C _3498_/B vdd gnd OAI21X1
X_3635_ _3966_/Q _3638_/C vdd gnd INVX1
XFILL_1__2564_ vdd gnd FILL
X_2379_ _3461_/B _3461_/A _2424_/B vdd gnd NAND2X1
XFILL_0__3909_ vdd gnd FILL
X_2448_ _3457_/B _3905_/Y _2448_/C _2461_/C vdd gnd NAND3X1
X_4118_ _4118_/D _4146_/CLK _4118_/Q vdd gnd DFFPOSX1
XFILL_1__3682_ vdd gnd FILL
X_4049_ _4049_/D _4049_/CLK _4049_/Q vdd gnd DFFPOSX1
XFILL131550x64950 vdd gnd FILL
XFILL_1_BUFX2_insert100 vdd gnd FILL
XFILL_1_BUFX2_insert122 vdd gnd FILL
XFILL_0__2240_ vdd gnd FILL
X_3351_ _3351_/A _3351_/B _3353_/A vdd gnd NAND2X1
X_3420_ _3422_/B _3420_/B _3430_/S _4094_/D vdd gnd MUX2X1
XFILL132750x126150 vdd gnd FILL
X_2302_ _3336_/A _3359_/D _2312_/A vdd gnd NAND2X1
X_3282_ _4125_/Q _3309_/B _3282_/C _3284_/B vdd gnd OAI21X1
X_2164_ _2164_/A _2164_/B _2182_/C _2166_/C vdd gnd OAI21X1
X_2233_ _3728_/B _2648_/B _2236_/B vdd gnd NOR2X1
XFILL_0__3625_ vdd gnd FILL
X_2095_ _2095_/A _4132_/Q _2158_/S _2096_/B vdd gnd MUX2X1
XFILL_0__3556_ vdd gnd FILL
XFILL_0__2438_ vdd gnd FILL
X_2997_ _2997_/A _2997_/B _3898_/D vdd gnd AND2X2
X_1948_ _1948_/A _4165_/Q _1949_/B vdd gnd OR2X2
X_3549_ _3593_/A _4025_/Q _3549_/C _3551_/B vdd gnd OAI21X1
X_3618_ _3618_/A _3618_/B _3622_/A _3984_/D vdd gnd MUX2X1
XFILL_1__2616_ vdd gnd FILL
XFILL_0_BUFX2_insert118 vdd gnd FILL
XFILL_0_BUFX2_insert107 vdd gnd FILL
X_2920_ _2928_/A _2920_/B _2920_/C _2921_/A vdd gnd OAI21X1
XFILL_0__3341_ vdd gnd FILL
X_2851_ _3971_/Q _2864_/A _2852_/C vdd gnd NAND2X1
X_2782_ _4003_/Q _4001_/Q _3019_/A _2784_/B vdd gnd MUX2X1
XFILL_0__2223_ vdd gnd FILL
XFILL_0__2154_ vdd gnd FILL
X_3334_ _4140_/Q _3363_/B _3334_/C _3335_/A vdd gnd OAI21X1
X_3403_ _4110_/Q _3406_/B vdd gnd INVX1
X_3265_ _4164_/Q _3267_/A vdd gnd INVX1
X_3196_ _3196_/A _3351_/B _3270_/C _4192_/D vdd gnd OAI21X1
XFILL_1__2401_ vdd gnd FILL
X_2147_ _4102_/Q _3953_/Q _2165_/S _2148_/B vdd gnd MUX2X1
XFILL_0__1938_ vdd gnd FILL
X_2216_ _2649_/A _4047_/Q _2217_/A vdd gnd NAND2X1
XFILL_0__3539_ vdd gnd FILL
XFILL_1__2194_ vdd gnd FILL
X_2078_ _2177_/A _2078_/B _4136_/D vdd gnd NOR2X1
XFILL_1__3717_ vdd gnd FILL
XFILL_1__1978_ vdd gnd FILL
XFILL_0__2841_ vdd gnd FILL
XFILL_1_CLKBUF1_insert162 vdd gnd FILL
XFILL_1_CLKBUF1_insert140 vdd gnd FILL
X_3050_ _3050_/A _3053_/A _3050_/C _3870_/D vdd gnd AOI21X1
X_2001_ _2001_/A _2163_/B _2002_/A vdd gnd NOR2X1
X_3952_ _3952_/D _3987_/CLK _3952_/Q vdd gnd DFFPOSX1
X_2903_ _2903_/A _2903_/B _2903_/C _2904_/A vdd gnd OAI21X1
XFILL_0__3255_ vdd gnd FILL
X_3883_ _3883_/D _3961_/CLK _3883_/Q vdd gnd DFFPOSX1
X_2834_ _3977_/Q _3975_/Q _2994_/S _2836_/B vdd gnd MUX2X1
X_2765_ _4014_/Q _2765_/B _2766_/B vdd gnd NAND2X1
X_2696_ _4030_/Q _2707_/A vdd gnd INVX1
XFILL_0__3186_ vdd gnd FILL
XFILL_0__2137_ vdd gnd FILL
XFILL_0__2068_ vdd gnd FILL
XFILL_1__2881_ vdd gnd FILL
XCLKBUF1_insert161 CLKBUF1_insert191/Y _4039_/CLK vdd gnd CLKBUF1
X_3317_ _3323_/C _3325_/B _3388_/A vdd gnd AND2X2
XCLKBUF1_insert150 CLKBUF1_insert186/Y _4084_/CLK vdd gnd CLKBUF1
X_3248_ _3248_/A _3248_/B _3378_/B _3249_/A vdd gnd OAI21X1
X_3179_ _4180_/R _4179_/Q _3180_/A vdd gnd NAND2X1
XFILL_1__3295_ vdd gnd FILL
X_2550_ _2550_/A _2550_/B _2551_/A vdd gnd NOR2X1
X_2481_ _3872_/Q _2516_/B _2685_/S _2544_/A _2600_/A vdd gnd AOI22X1
X_4151_ _4151_/D _4197_/CLK _4151_/Q vdd gnd DFFPOSX1
X_3102_ _3841_/Q _3107_/A _3117_/A vdd gnd NAND2X1
XFILL_0__2755_ vdd gnd FILL
X_3033_ _3033_/A _3053_/A _3033_/C _3880_/D vdd gnd AOI21X1
X_4082_ _4082_/D _4084_/CLK _4082_/Q vdd gnd DFFPOSX1
X_3866_ _3866_/D _4039_/CLK _3866_/Q vdd gnd DFFPOSX1
X_3935_ vdd _3947_/S _3935_/D _4121_/D _3935_/Q vdd gnd DFFSR
XFILL_1__2031_ vdd gnd FILL
X_2748_ _3025_/S _3019_/B _2748_/C _2752_/A vdd gnd OAI21X1
X_2817_ _2817_/A _3009_/B _3989_/D vdd gnd AND2X2
XFILL_1__2933_ vdd gnd FILL
X_2679_ _4039_/Q _2682_/C _2684_/A vdd gnd NOR2X1
XFILL_0__3169_ vdd gnd FILL
X_3797_ _3798_/A _3935_/Q _3930_/Q _3798_/C vdd gnd NAND3X1
XFILL_1__3347_ vdd gnd FILL
XFILL132750x93750 vdd gnd FILL
XFILL_1__2229_ vdd gnd FILL
XFILL_0__2540_ vdd gnd FILL
XFILL_0__2471_ vdd gnd FILL
XFILL_0_CLKBUF1_insert67 vdd gnd FILL
XFILL132150x100950 vdd gnd FILL
X_3720_ _3720_/A _3720_/B _3848_/D vdd gnd NAND2X1
X_1981_ _3758_/B _2170_/B _1984_/B vdd gnd NOR2X1
X_2533_ _4056_/Q _2535_/A vdd gnd INVX1
X_2602_ _2602_/A _2607_/B _2602_/C _4062_/D vdd gnd AOI21X1
X_3651_ _3933_/Q _3654_/C vdd gnd INVX1
X_3582_ _4002_/Q _3611_/A _3583_/C vdd gnd NOR2X1
XFILL_0__2738_ vdd gnd FILL
X_2464_ _4033_/Q _3054_/B vdd gnd INVX1
X_2395_ _3817_/Q _3479_/A _3449_/C vdd gnd NOR2X1
X_4134_ _4134_/D _4148_/CLK _4134_/Q vdd gnd DFFPOSX1
X_3016_ _3884_/Q _3022_/A vdd gnd INVX1
XFILL_0__2669_ vdd gnd FILL
XFILL_1__3132_ vdd gnd FILL
X_4065_ _4065_/D _4106_/CLK _4065_/Q vdd gnd DFFPOSX1
XFILL132750x25350 vdd gnd FILL
X_3849_ _3849_/D _4172_/CLK _3849_/Q vdd gnd DFFPOSX1
X_3918_ _3918_/D _4030_/CLK _3918_/Q vdd gnd DFFPOSX1
XFILL132150x21750 vdd gnd FILL
XFILL_1__2916_ vdd gnd FILL
X_2180_ _2180_/A _4038_/Q _2181_/A vdd gnd NAND2X1
XFILL_0__3710_ vdd gnd FILL
XFILL_0__1971_ vdd gnd FILL
XFILL_0__2454_ vdd gnd FILL
XFILL_0__3572_ vdd gnd FILL
XFILL_0__3006_ vdd gnd FILL
XBUFX2_insert181 _3629_/Y _3672_/D vdd gnd BUFX2
X_1964_ _1964_/A _1964_/B _1965_/B vdd gnd NOR2X1
X_3634_ _3636_/C _3683_/B _3634_/C _3683_/D _3970_/D vdd gnd OAI22X1
X_3703_ _3703_/A _3716_/C vdd gnd INVX1
XFILL_0__2385_ vdd gnd FILL
X_2516_ _4019_/Q _2516_/B _2518_/B vdd gnd NAND2X1
X_2447_ _4178_/Q _3720_/A _3720_/B _2448_/C vdd gnd OAI21X1
X_3565_ _3593_/A _4012_/Q _3565_/C _3567_/B vdd gnd OAI21X1
X_3496_ _3496_/A _3496_/B _3525_/B _3497_/B vdd gnd MUX2X1
X_2378_ _4131_/Q _2378_/B _3378_/B _3461_/B vdd gnd NAND3X1
X_4117_ _4117_/D _4196_/CLK _4117_/Q vdd gnd DFFPOSX1
X_4048_ _4048_/D _3214_/A _4048_/Q vdd gnd DFFPOSX1
XFILL_0__2170_ vdd gnd FILL
X_2301_ _4133_/Q _3359_/D vdd gnd INVX1
X_3350_ _4144_/Q _3350_/B _3350_/C _3351_/A vdd gnd OAI21X1
XFILL_0__1954_ vdd gnd FILL
X_3281_ _3281_/A _3351_/B _3282_/C vdd gnd NAND2X1
X_2232_ _4101_/Q _3728_/B vdd gnd INVX1
X_2163_ _2163_/A _2163_/B _2164_/A vdd gnd NOR2X1
XFILL_0__2506_ vdd gnd FILL
XFILL_0__2368_ vdd gnd FILL
X_2094_ _2155_/C _2094_/B _2094_/C _2095_/A vdd gnd OAI21X1
XFILL_0__3486_ vdd gnd FILL
X_2996_ _3008_/A _2996_/B _2996_/C _2997_/A vdd gnd OAI21X1
XFILL_0__2299_ vdd gnd FILL
X_1947_ _3715_/B _3721_/A _1958_/A _3223_/B vdd gnd NAND3X1
X_3617_ _3617_/A _3986_/Q _3617_/C _3618_/A vdd gnd OAI21X1
X_3479_ _3479_/A _3479_/B _3487_/B _3480_/A vdd gnd OAI21X1
X_3548_ _3593_/A _3740_/B _3549_/C vdd gnd NAND2X1
XFILL_1__3664_ vdd gnd FILL
XFILL_1__2546_ vdd gnd FILL
XFILL132450x90150 vdd gnd FILL
X_2850_ _3969_/Q _3967_/Q _2878_/S _2852_/B vdd gnd MUX2X1
XFILL_0__3271_ vdd gnd FILL
XFILL_0__2222_ vdd gnd FILL
X_2781_ _3025_/S _2895_/B _2781_/Y vdd gnd NOR2X1
XFILL_0__2084_ vdd gnd FILL
XFILL_0__2986_ vdd gnd FILL
X_3264_ _3264_/A _3370_/B _3264_/C _3264_/D _4166_/D vdd gnd AOI22X1
X_3333_ _3333_/A _3747_/A _3334_/C vdd gnd NAND2X1
X_3402_ _3404_/B _3402_/B _3448_/S _4112_/D vdd gnd MUX2X1
X_3195_ _3794_/B _3351_/B _3270_/C vdd gnd NAND2X1
XFILL_0__3607_ vdd gnd FILL
X_2146_ _2146_/A _2146_/B _2155_/C _2148_/C vdd gnd OAI21X1
X_2215_ _3730_/B _2648_/B _2218_/B vdd gnd NOR2X1
X_2077_ _2077_/A _4136_/Q _2131_/S _2078_/B vdd gnd MUX2X1
X_2979_ _3906_/Q _2992_/A _2980_/C vdd gnd NAND2X1
XFILL_0__3469_ vdd gnd FILL
XFILL_1__3647_ vdd gnd FILL
XFILL_0__2771_ vdd gnd FILL
X_2000_ _2153_/A _3992_/Q _2001_/A vdd gnd NAND2X1
X_2902_ _3946_/Q _2903_/A _2903_/C vdd gnd NAND2X1
X_3882_ _3882_/D _4019_/CLK _3882_/Q vdd gnd DFFPOSX1
X_2833_ _2833_/A _2997_/B _3981_/D vdd gnd AND2X2
XFILL_0__3323_ vdd gnd FILL
X_3951_ _4201_/R vdd _3951_/D _4182_/CLK _3951_/Q vdd gnd DFFSR
XFILL_0__2205_ vdd gnd FILL
X_2764_ _2764_/A _2764_/B _2764_/C _2766_/A vdd gnd OAI21X1
X_2695_ _2778_/C _2778_/B _2705_/B vdd gnd NOR2X1
XCLKBUF1_insert151 CLKBUF1_insert189/Y _3997_/CLK vdd gnd CLKBUF1
XFILL_0__2969_ vdd gnd FILL
XCLKBUF1_insert162 CLKBUF1_insert189/Y _4173_/CLK vdd gnd CLKBUF1
X_3316_ _4123_/Q _3325_/B _3391_/S _3318_/D vdd gnd OAI21X1
X_3247_ _4190_/Q _4189_/Q _3248_/B vdd gnd NOR2X1
XCLKBUF1_insert140 CLKBUF1_insert190/Y _4201_/CLK vdd gnd CLKBUF1
XFILL_1__3501_ vdd gnd FILL
X_3178_ _4192_/Q _3695_/B _3457_/B _3181_/A vdd gnd OAI21X1
X_2129_ _4098_/Q _3945_/Q _2165_/S _2130_/B vdd gnd MUX2X1
XFILL_1__2176_ vdd gnd FILL
X_2480_ _2543_/B _3347_/A _2544_/A vdd gnd NOR2X1
XFILL_0__2823_ vdd gnd FILL
X_4081_ _4081_/D _2244_/A _4081_/Q vdd gnd DFFPOSX1
X_3101_ _3252_/C _3101_/B _3141_/C _3843_/D vdd gnd AOI21X1
X_4150_ _4150_/D _4157_/CLK _4150_/Q vdd gnd DFFPOSX1
X_3032_ _3880_/Q _3107_/A _3136_/B _3033_/C vdd gnd OAI21X1
XFILL_0__2685_ vdd gnd FILL
X_2816_ _2827_/B _2816_/B _2816_/C _2817_/A vdd gnd OAI21X1
X_3934_ _3934_/D _4184_/CLK _3934_/Q vdd gnd DFFPOSX1
X_3865_ _3865_/D _4199_/CLK _3865_/Q vdd gnd DFFPOSX1
XFILL_0__3237_ vdd gnd FILL
XFILL_0__3306_ vdd gnd FILL
X_3796_ _4159_/Q _4161_/Q _3798_/B vdd gnd NAND2X1
XFILL_0__2119_ vdd gnd FILL
XFILL_1__2863_ vdd gnd FILL
X_2747_ _2747_/A _2747_/B _2747_/C _4024_/D vdd gnd AOI21X1
X_2678_ _2678_/A _2678_/B _2682_/C vdd gnd NOR2X1
XFILL_0__3099_ vdd gnd FILL
XFILL_1__3277_ vdd gnd FILL
XFILL_1__2159_ vdd gnd FILL
XFILL_0__3022_ vdd gnd FILL
X_3650_ _3652_/C _3662_/B _3650_/C _3672_/D _3937_/D vdd gnd OAI22X1
X_1980_ _2181_/B _1980_/Y vdd gnd INVX8
X_2601_ _4062_/Q _2607_/B _2758_/A _2602_/C vdd gnd OAI21X1
X_2532_ _2532_/A _2532_/B _2540_/A vdd gnd AND2X2
X_2463_ _2463_/A _3144_/A _2463_/C _2689_/A vdd gnd OAI21X1
X_4202_ _4202_/D _3214_/A _4202_/Q vdd gnd DFFPOSX1
X_3581_ _3620_/A _4004_/Q _3581_/C _3583_/B vdd gnd OAI21X1
XFILL_0__2737_ vdd gnd FILL
X_4064_ _4064_/D _4089_/CLK _4064_/Q vdd gnd DFFPOSX1
XFILL_0__2806_ vdd gnd FILL
X_3015_ _3015_/A _3015_/B _3038_/C _3890_/D vdd gnd AOI21X1
X_4133_ _4133_/D _4135_/CLK _4133_/Q vdd gnd DFFPOSX1
X_2394_ _3487_/A _3479_/A vdd gnd INVX1
XFILL_0__3786_ vdd gnd FILL
XFILL_0__2599_ vdd gnd FILL
X_3917_ _3917_/A _4199_/Q _3917_/Y vdd gnd NOR2X1
X_3848_ _3848_/D _4193_/CLK _3848_/Q vdd gnd DFFPOSX1
X_3779_ _3787_/B _3813_/B vdd gnd INVX1
XFILL_1__2013_ vdd gnd FILL
XFILL_0__3640_ vdd gnd FILL
XFILL_0__2522_ vdd gnd FILL
X_1963_ _3718_/A i_mem_miso _1963_/C _1964_/B vdd gnd OAI21X1
XBUFX2_insert182 _3629_/Y _3683_/D vdd gnd BUFX2
X_3633_ _3970_/Q _3636_/C vdd gnd INVX1
X_3702_ _3702_/A _3717_/B _3703_/A vdd gnd NAND2X1
X_2515_ _2515_/A _2515_/B _2551_/B vdd gnd NOR2X1
XFILL_1__2700_ vdd gnd FILL
X_2446_ _3848_/Q _2446_/B _3720_/A vdd gnd NAND2X1
X_3495_ _3495_/A _3495_/B _3496_/A vdd gnd NOR2X1
X_3564_ _3593_/A _3744_/B _3565_/C vdd gnd NAND2X1
XFILL_1__2493_ vdd gnd FILL
X_2377_ _2377_/A _3237_/A _3378_/B vdd gnd OR2X2
X_4047_ _4047_/D _4049_/CLK _4047_/Q vdd gnd DFFPOSX1
X_4116_ _4116_/D _4148_/CLK _4116_/Q vdd gnd DFFPOSX1
XFILL_1__3114_ vdd gnd FILL
XFILL_1_BUFX2_insert113 vdd gnd FILL
XFILL_1_BUFX2_insert179 vdd gnd FILL
X_2300_ _4115_/Q _3336_/A vdd gnd INVX1
X_3280_ _4101_/Q _3286_/A _3280_/C _3281_/A vdd gnd OAI21X1
X_2231_ _2655_/A _2231_/B _4101_/D vdd gnd NOR2X1
XFILL_0__3554_ vdd gnd FILL
X_2093_ _4088_/Q _3928_/Q _2120_/S _2094_/B vdd gnd MUX2X1
X_2162_ _2171_/A _4036_/Q _2163_/A vdd gnd NAND2X1
XFILL_0__3623_ vdd gnd FILL
X_2995_ _3898_/Q _3008_/A _2996_/C vdd gnd NAND2X1
XFILL_0__2436_ vdd gnd FILL
XFILL_1__3801_ vdd gnd FILL
X_3616_ _3617_/A _3760_/B _3617_/C vdd gnd NAND2X1
X_3547_ _3607_/A _3547_/B _3547_/C _4025_/D vdd gnd AOI21X1
X_1946_ _1946_/A _1958_/A vdd gnd INVX1
X_2429_ _4178_/Q _3172_/A _2429_/C _2434_/B vdd gnd NAND3X1
X_3478_ _3478_/A _3478_/B _3478_/C _3481_/A vdd gnd OAI21X1
XFILL_1__3594_ vdd gnd FILL
XFILL_1__2476_ vdd gnd FILL
XFILL_0_BUFX2_insert109 vdd gnd FILL
XFILL131850x93750 vdd gnd FILL
XFILL_0__3270_ vdd gnd FILL
XFILL_0__2152_ vdd gnd FILL
X_2780_ _2780_/A _2780_/B _4007_/D vdd gnd NOR2X1
X_3401_ _4112_/Q _3404_/B vdd gnd INVX1
X_3263_ _4168_/Q _3272_/B _3364_/A _3264_/D vdd gnd OAI21X1
X_3332_ _3972_/Q _3747_/A vdd gnd INVX1
X_3194_ _3745_/A _3745_/B _3363_/B _3794_/B vdd gnd MUX2X1
X_2214_ _4105_/Q _3730_/B vdd gnd INVX1
XFILL_0__1936_ vdd gnd FILL
XFILL_1__2330_ vdd gnd FILL
X_2145_ _2145_/A _2154_/B _2146_/A vdd gnd NOR2X1
XFILL_0__3537_ vdd gnd FILL
X_2076_ _2182_/C _2076_/B _2076_/C _2077_/A vdd gnd OAI21X1
XFILL_0__3468_ vdd gnd FILL
X_2978_ _3904_/Q _3902_/Q _2986_/S _2980_/B vdd gnd MUX2X1
X_1929_ _4165_/Q _1945_/A vdd gnd INVX1
XFILL_1__2528_ vdd gnd FILL
XFILL_1_CLKBUF1_insert153 vdd gnd FILL
XFILL_1_CLKBUF1_insert131 vdd gnd FILL
X_3950_ _3950_/D _3987_/CLK _3950_/Q vdd gnd DFFPOSX1
X_2901_ _4026_/Q _4028_/Q _3025_/S _2903_/B vdd gnd MUX2X1
X_2832_ _2843_/B _2832_/B _2832_/C _2833_/A vdd gnd OAI21X1
XFILL_0__3253_ vdd gnd FILL
X_2763_ _2763_/A _4015_/D vdd gnd INVX1
XFILL_0__3184_ vdd gnd FILL
XFILL_0__2135_ vdd gnd FILL
X_3881_ _3881_/D _4101_/CLK _3881_/Q vdd gnd DFFPOSX1
X_2694_ _4009_/Q _2776_/B _2778_/B vdd gnd NAND2X1
XFILL_0__2066_ vdd gnd FILL
XCLKBUF1_insert163 CLKBUF1_insert187/Y _4052_/CLK vdd gnd CLKBUF1
XCLKBUF1_insert141 CLKBUF1_insert189/Y _3985_/CLK vdd gnd CLKBUF1
X_3315_ _3315_/A _3478_/C _3325_/B vdd gnd NAND2X1
X_3246_ _4173_/Q _3252_/A vdd gnd INVX1
X_3177_ _3695_/B _4192_/Q _3181_/B vdd gnd AND2X2
XCLKBUF1_insert130 CLKBUF1_insert186/Y _4071_/CLK vdd gnd CLKBUF1
XFILL_1__3431_ vdd gnd FILL
XFILL_0__1919_ vdd gnd FILL
XCLKBUF1_insert152 CLKBUF1_insert188/Y _4036_/CLK vdd gnd CLKBUF1
XFILL_1__2313_ vdd gnd FILL
X_2059_ _2059_/A _4140_/Q _2131_/S _2060_/B vdd gnd MUX2X1
X_2128_ _2128_/A _2128_/B _2157_/A _2130_/C vdd gnd OAI21X1
XFILL_1__3629_ vdd gnd FILL
X_3031_ _3031_/A _3031_/B _3038_/C _3882_/D vdd gnd AOI21X1
XFILL_0__2753_ vdd gnd FILL
X_3100_ _3100_/A _3310_/B _3252_/C vdd gnd NAND2X1
X_4080_ _4080_/D _4084_/CLK _4080_/Q vdd gnd DFFPOSX1
XFILL_0__3305_ vdd gnd FILL
X_3933_ _3933_/D _4094_/CLK _3933_/Q vdd gnd DFFPOSX1
X_2746_ _2746_/A _3019_/B _2747_/A vdd gnd NAND2X1
X_2815_ _3989_/Q _2827_/B _2816_/C vdd gnd NAND2X1
X_3864_ _3901_/A vdd _3864_/D _4189_/CLK _3864_/Q vdd gnd DFFSR
XFILL_0__3098_ vdd gnd FILL
XFILL_0__3167_ vdd gnd FILL
X_3795_ _3795_/A _3799_/C vdd gnd INVX1
XFILL_1__2793_ vdd gnd FILL
X_2677_ _3809_/A _2677_/B _2678_/A vdd gnd OR2X2
XFILL_0__2049_ vdd gnd FILL
X_3229_ _3955_/Q _3751_/A vdd gnd INVX1
XFILL_0_CLKBUF1_insert69 vdd gnd FILL
X_2600_ _2600_/A _2607_/B _2600_/C _4064_/D vdd gnd AOI21X1
X_3580_ _3617_/A _3748_/B _3581_/C vdd gnd NAND2X1
X_2531_ _3809_/A _4095_/Q _2532_/A vdd gnd OR2X2
X_4201_ _4201_/R vdd _4201_/D _4201_/CLK _4201_/Q vdd gnd DFFSR
X_2462_ _2462_/A _2462_/B _2462_/C _2463_/C vdd gnd AOI21X1
X_2393_ _3818_/Q _4200_/Q _3487_/A vdd gnd NOR2X1
X_3014_ _3890_/Q _3027_/A _3015_/A vdd gnd NAND2X1
XFILL_0__2667_ vdd gnd FILL
X_4132_ _4132_/D _4146_/CLK _4132_/Q vdd gnd DFFPOSX1
X_4063_ _4063_/D _4114_/CLK _4063_/Q vdd gnd DFFPOSX1
XFILL_0__3785_ vdd gnd FILL
XFILL_1__3061_ vdd gnd FILL
X_3916_ _3916_/D _4032_/CLK _3916_/Q vdd gnd DFFPOSX1
X_2729_ _3872_/Q _3874_/Q _2730_/C vdd gnd NOR2X1
X_3847_ _3847_/D _4172_/CLK _3847_/Q vdd gnd DFFPOSX1
X_3778_ _3893_/Q _3783_/B _3787_/B vdd gnd NAND2X1
XFILL_1__2845_ vdd gnd FILL
XFILL132450x75750 vdd gnd FILL
XFILL_1__3259_ vdd gnd FILL
XFILL_0__3570_ vdd gnd FILL
XFILL_0__2383_ vdd gnd FILL
XFILL_0__2452_ vdd gnd FILL
X_1962_ _3846_/Q _1976_/C _1963_/C vdd gnd NOR2X1
XBUFX2_insert172 _2634_/Y _3107_/A vdd gnd BUFX2
XFILL_0__3004_ vdd gnd FILL
X_3563_ _3607_/A _3563_/B _3563_/C _4012_/D vdd gnd AOI21X1
X_3701_ _3701_/A _3701_/B _3717_/B vdd gnd NOR2X1
X_3632_ _3634_/C _3683_/B _3632_/C _3683_/D _3974_/D vdd gnd OAI22X1
XBUFX2_insert183 _3629_/Y _3688_/D vdd gnd BUFX2
XFILL_1__2630_ vdd gnd FILL
X_2514_ _4064_/Q _2600_/A _2514_/C _2515_/B vdd gnd OAI21X1
X_4115_ _4115_/D _4139_/CLK _4115_/Q vdd gnd DFFPOSX1
X_2376_ _3151_/A _2376_/B _2376_/C _3461_/A vdd gnd NAND3X1
X_2445_ _2445_/A _2445_/B _2445_/C _3720_/B vdd gnd OAI21X1
X_3494_ _3504_/B _3503_/A _3495_/B vdd gnd NOR2X1
X_4046_ _4046_/D _4148_/CLK _4046_/Q vdd gnd DFFPOSX1
XFILL_0__3768_ vdd gnd FILL
XFILL_1__3044_ vdd gnd FILL
XFILL132450x50550 vdd gnd FILL
XFILL_1__2828_ vdd gnd FILL
XFILL_0__3622_ vdd gnd FILL
X_2230_ _2230_/A _4101_/Q _2654_/S _2231_/B vdd gnd MUX2X1
XFILL_0__1952_ vdd gnd FILL
XFILL_0__2504_ vdd gnd FILL
X_2092_ _2092_/A _2092_/B _2155_/C _2094_/C vdd gnd OAI21X1
X_2161_ _3736_/B _2179_/B _2164_/B vdd gnd NOR2X1
XFILL_0__3484_ vdd gnd FILL
X_2994_ _3896_/Q _3894_/Q _2994_/S _2996_/B vdd gnd MUX2X1
XFILL_0__2366_ vdd gnd FILL
XFILL_0__2297_ vdd gnd FILL
X_1945_ _1945_/A _3696_/A _3698_/A _1946_/A vdd gnd NAND3X1
X_3615_ _4161_/Q _3760_/B vdd gnd INVX1
X_3546_ _4025_/Q _3607_/A _3547_/C vdd gnd NOR2X1
X_2359_ _3962_/Q _2370_/A vdd gnd INVX1
X_2428_ _2428_/A _3022_/B _3624_/A _3172_/A vdd gnd OAI21X1
X_3477_ _3818_/Q _4061_/Q _4200_/Q _3924_/Q _3478_/B vdd gnd AOI22X1
X_4029_ _4029_/D _4034_/CLK _4029_/Q vdd gnd DFFPOSX1
XFILL_0__2220_ vdd gnd FILL
X_3331_ _3344_/A _3393_/A _3337_/C vdd gnd NAND2X1
XFILL_0__2082_ vdd gnd FILL
X_3400_ _3402_/B _3400_/B _3448_/S _4114_/D vdd gnd MUX2X1
XFILL_0__2984_ vdd gnd FILL
X_3262_ _4166_/Q _3264_/A vdd gnd INVX1
X_3193_ _4175_/Q _3745_/A vdd gnd INVX1
XFILL_0__3605_ vdd gnd FILL
X_2144_ _2153_/A _4029_/Q _2145_/A vdd gnd NAND2X1
X_2213_ _2655_/A _2213_/B _4105_/D vdd gnd NOR2X1
XFILL_0__2418_ vdd gnd FILL
XFILL_1__2260_ vdd gnd FILL
X_2075_ _4084_/Q _3919_/Q _2120_/S _2076_/B vdd gnd MUX2X1
XFILL_0__3398_ vdd gnd FILL
X_2977_ _2977_/A _2997_/B _3908_/D vdd gnd AND2X2
X_1928_ _4167_/Q _1928_/B _1928_/C _4167_/D vdd gnd AOI21X1
X_3529_ _3617_/A _3982_/Q _3529_/C _3531_/B vdd gnd OAI21X1
XFILL_1__3576_ vdd gnd FILL
XFILL_1__2458_ vdd gnd FILL
X_2900_ _2900_/A _2900_/B _2900_/C _3948_/D vdd gnd AOI21X1
XFILL_0__3321_ vdd gnd FILL
XFILL_0__3252_ vdd gnd FILL
X_2831_ _3981_/Q _2843_/B _2832_/C vdd gnd NAND2X1
X_3880_ _3880_/D _4054_/CLK _3880_/Q vdd gnd DFFPOSX1
X_2762_ _2764_/A _2766_/C _2763_/A vdd gnd NAND2X1
XFILL_0__2134_ vdd gnd FILL
XFILL_0__2203_ vdd gnd FILL
XFILL_0__2967_ vdd gnd FILL
X_3314_ _3909_/Y _3905_/Y _3314_/C _3315_/A vdd gnd OAI21X1
X_2693_ _2771_/A _2771_/B _2776_/B vdd gnd NOR2X1
XCLKBUF1_insert131 CLKBUF1_insert190/Y _4166_/CLK vdd gnd CLKBUF1
XCLKBUF1_insert142 CLKBUF1_insert188/Y _4027_/CLK vdd gnd CLKBUF1
XFILL_0__2898_ vdd gnd FILL
XCLKBUF1_insert153 CLKBUF1_insert189/Y _4003_/CLK vdd gnd CLKBUF1
X_3176_ _3176_/A _3176_/B _3695_/B vdd gnd NOR2X1
XFILL_1__3361_ vdd gnd FILL
XCLKBUF1_insert164 CLKBUF1_insert190/Y _4030_/CLK vdd gnd CLKBUF1
X_3245_ _3472_/B _3245_/B _3383_/B _4174_/D vdd gnd OAI21X1
X_2127_ _2127_/A _2154_/B _2128_/A vdd gnd NOR2X1
XFILL_0__1918_ vdd gnd FILL
XCLKBUF1_insert186 _3881_/Q CLKBUF1_insert186/Y vdd gnd CLKBUF1
XFILL_0__3519_ vdd gnd FILL
X_2058_ _2182_/C _2058_/B _2058_/C _2059_/A vdd gnd OAI21X1
XFILL_1__3559_ vdd gnd FILL
XFILL_0__2821_ vdd gnd FILL
X_3030_ _3839_/Q _3035_/B _3031_/A vdd gnd NAND2X1
XFILL_0__2683_ vdd gnd FILL
X_3932_ _3932_/D _4184_/CLK _3932_/Q vdd gnd DFFPOSX1
X_3863_ _3863_/D _4039_/CLK _3863_/Q vdd gnd DFFPOSX1
XFILL_0__3235_ vdd gnd FILL
X_2745_ _2751_/C _3019_/B vdd gnd INVX2
X_2814_ _3987_/Q _3985_/Q _2994_/S _2816_/B vdd gnd MUX2X1
X_2676_ _2676_/A _3152_/A _3926_/A _4040_/D vdd gnd AOI21X1
X_3794_ _3794_/A _3794_/B _3794_/C _3794_/D _3801_/B vdd gnd AOI22X1
XFILL_0__2117_ vdd gnd FILL
X_3159_ _3159_/A _3159_/B _3159_/C _3817_/D vdd gnd AOI21X1
X_3228_ _3228_/A _3228_/B _3240_/C _4181_/D vdd gnd AOI21X1
XFILL_1__3413_ vdd gnd FILL
XFILL_1__2088_ vdd gnd FILL
XFILL_0__3020_ vdd gnd FILL
X_2530_ _2530_/A _2530_/B _4095_/Q _2532_/B vdd gnd OAI21X1
XFILL_0__2804_ vdd gnd FILL
X_4131_ _4131_/D _4191_/CLK _4131_/Q vdd gnd DFFPOSX1
X_2392_ _2392_/A _2392_/B _2392_/C _3689_/A vdd gnd NAND3X1
X_2461_ _2461_/A _3145_/A _2461_/C _2462_/C vdd gnd OAI21X1
X_4200_ _4200_/D _4200_/CLK _4200_/Q vdd gnd DFFPOSX1
XFILL_0__2735_ vdd gnd FILL
XFILL_0__2597_ vdd gnd FILL
X_4062_ _4062_/D _4089_/CLK _4062_/Q vdd gnd DFFPOSX1
X_3013_ _3019_/A _3019_/B _3013_/C _3015_/B vdd gnd OAI21X1
X_3846_ _3846_/D _4183_/CLK _3846_/Q vdd gnd DFFPOSX1
X_3915_ _3915_/D _4071_/CLK _3915_/Q vdd gnd DFFPOSX1
XFILL_0__3218_ vdd gnd FILL
X_2728_ _3868_/Q _3870_/Q _2730_/B vdd gnd NOR2X1
X_2659_ _3369_/B _3369_/A _2660_/A vdd gnd NAND2X1
XFILL_0__3149_ vdd gnd FILL
X_3777_ _3889_/Q _3885_/Q _3783_/B vdd gnd AND2X2
XFILL_1__2775_ vdd gnd FILL
XFILL_1__3189_ vdd gnd FILL
XFILL_0__2520_ vdd gnd FILL
XFILL_0__2451_ vdd gnd FILL
X_3700_ _3846_/Q _4169_/Q _3701_/A vdd gnd NAND2X1
X_1961_ _2645_/A _1976_/C vdd gnd INVX1
X_2513_ _4066_/Q _2513_/B _2513_/C _2514_/C vdd gnd NAND3X1
XBUFX2_insert173 _2634_/Y _3049_/B vdd gnd BUFX2
XBUFX2_insert184 _3629_/Y _3680_/D vdd gnd BUFX2
X_3493_ _4047_/Q _3493_/B _3495_/A vdd gnd NOR2X1
X_3562_ _4012_/Q _3607_/A _3563_/C vdd gnd NOR2X1
X_3631_ _3974_/Q _3634_/C vdd gnd INVX1
X_2375_ _3359_/D _4191_/Q _2375_/C _2376_/C vdd gnd NAND3X1
X_4114_ _4114_/D _4114_/CLK _4114_/Q vdd gnd DFFPOSX1
X_2444_ _3704_/B _2444_/B _2444_/C _2445_/B vdd gnd OAI21X1
XFILL_0__2718_ vdd gnd FILL
X_4045_ _4045_/D _4049_/CLK _4045_/Q vdd gnd DFFPOSX1
XFILL_0__3698_ vdd gnd FILL
XFILL_0__2649_ vdd gnd FILL
X_3829_ _3829_/D _4054_/CLK _3829_/Q vdd gnd DFFPOSX1
X_2160_ _4118_/Q _3736_/B vdd gnd INVX1
XFILL_0__2434_ vdd gnd FILL
X_2091_ _2091_/A _2154_/B _2092_/A vdd gnd NOR2X1
XFILL_0__3552_ vdd gnd FILL
X_2993_ _2993_/A _2997_/B _3900_/D vdd gnd AND2X2
X_1944_ _3846_/Q _4163_/Q _3721_/A vdd gnd NOR2X1
X_3614_ _3614_/A _3614_/B _3622_/A _3986_/D vdd gnd MUX2X1
X_2427_ _3708_/A _3172_/C _2427_/C _2429_/C vdd gnd OAI21X1
XFILL_1__3730_ vdd gnd FILL
X_3476_ _4200_/Q _3924_/Q _3478_/A vdd gnd NOR2X1
X_3545_ _3605_/A _4027_/Q _3545_/C _3547_/B vdd gnd OAI21X1
XFILL_1__1991_ vdd gnd FILL
X_4028_ _4028_/D _4050_/CLK _4028_/Q vdd gnd DFFPOSX1
XFILL_1__2612_ vdd gnd FILL
X_2358_ _4190_/Q _2402_/B _2463_/A vdd gnd NAND2X1
X_2289_ _2387_/B _4178_/Q _2289_/C _2314_/B vdd gnd AOI21X1
XFILL_1__3026_ vdd gnd FILL
XFILL_0__2150_ vdd gnd FILL
XFILL_0__2081_ vdd gnd FILL
X_3330_ _3352_/B _3802_/B _3393_/A vdd gnd NOR2X1
X_3261_ _3261_/A _3370_/B _3261_/C _3261_/D _4168_/D vdd gnd AOI22X1
X_3192_ _3708_/A _3245_/B _3267_/C _4193_/D vdd gnd OAI21X1
XFILL_0__3535_ vdd gnd FILL
X_2143_ _3738_/B _2152_/B _2146_/B vdd gnd NOR2X1
XFILL_0__1934_ vdd gnd FILL
X_2212_ _2212_/A _4105_/Q _2654_/S _2213_/B vdd gnd MUX2X1
XFILL_0__2348_ vdd gnd FILL
XFILL_0__3466_ vdd gnd FILL
X_2074_ _2074_/A _2074_/B _2175_/A _2076_/C vdd gnd OAI21X1
X_2976_ _2992_/A _2976_/B _2976_/C _2977_/A vdd gnd OAI21X1
XFILL_0__2279_ vdd gnd FILL
X_1927_ _4167_/Q _1928_/B _3771_/Y _1928_/C vdd gnd OAI21X1
X_3459_ _4188_/Q _3459_/B _3464_/A _3460_/A vdd gnd OAI21X1
X_3528_ _3617_/A _3735_/B _3529_/C vdd gnd NAND2X1
XFILL_1__3713_ vdd gnd FILL
XFILL_1__1974_ vdd gnd FILL
XFILL_1__2388_ vdd gnd FILL
XFILL_1_CLKBUF1_insert166 vdd gnd FILL
XFILL_1_CLKBUF1_insert144 vdd gnd FILL
XFILL_1_CLKBUF1_insert188 vdd gnd FILL
X_2830_ _3979_/Q _3977_/Q _2994_/S _2832_/B vdd gnd MUX2X1
XFILL132450x100950 vdd gnd FILL
XFILL_0__3182_ vdd gnd FILL
X_2761_ _3077_/C _3245_/B _2766_/C vdd gnd NOR2X1
X_2692_ _4013_/Q _2771_/B vdd gnd INVX1
XFILL_0__2064_ vdd gnd FILL
XCLKBUF1_insert132 CLKBUF1_insert189/Y _3977_/CLK vdd gnd CLKBUF1
X_3313_ _4147_/Q _3318_/A vdd gnd INVX1
XFILL_0__2966_ vdd gnd FILL
XCLKBUF1_insert143 CLKBUF1_insert190/Y _4184_/CLK vdd gnd CLKBUF1
X_3244_ _3793_/B _3245_/B _3383_/B vdd gnd NAND2X1
XCLKBUF1_insert154 CLKBUF1_insert186/Y _4114_/CLK vdd gnd CLKBUF1
XCLKBUF1_insert165 CLKBUF1_insert186/Y _3806_/A vdd gnd CLKBUF1
XCLKBUF1_insert187 _3881_/Q CLKBUF1_insert187/Y vdd gnd CLKBUF1
X_3175_ _3175_/A _3175_/B _3175_/C _3176_/B vdd gnd AOI21X1
X_2126_ _2153_/A _4025_/Q _2127_/A vdd gnd NAND2X1
X_2057_ _4080_/Q _3911_/Q _2228_/S _2058_/B vdd gnd MUX2X1
X_2959_ _3916_/Q _2972_/A _2960_/C vdd gnd NAND2X1
XFILL_0__3449_ vdd gnd FILL
XFILL_1__2242_ vdd gnd FILL
XFILL_0__2751_ vdd gnd FILL
X_2813_ _2813_/A _3009_/B _3991_/D vdd gnd AND2X2
XFILL_0__3303_ vdd gnd FILL
XFILL_0__3165_ vdd gnd FILL
X_3931_ _3931_/D _4119_/CLK _3931_/Q vdd gnd DFFPOSX1
X_3862_ _3862_/D _4119_/CLK _3862_/Q vdd gnd DFFPOSX1
X_2744_ _4024_/Q _2751_/C _2747_/B vdd gnd NAND2X1
XFILL_0__3096_ vdd gnd FILL
X_2675_ _2675_/A _2675_/B _3358_/C _2676_/A vdd gnd NAND3X1
X_3793_ _3794_/A _3793_/B _3793_/C _3794_/C vdd gnd NAND3X1
XFILL_0__2047_ vdd gnd FILL
XFILL_0__2949_ vdd gnd FILL
X_3227_ _4097_/Q _3227_/B _3947_/S _3240_/C vdd gnd OAI21X1
XFILL_1__3343_ vdd gnd FILL
X_3089_ _3741_/A _3741_/B _3390_/S _3090_/A vdd gnd MUX2X1
X_3158_ _3159_/A _3159_/B _3901_/A _3159_/C vdd gnd OAI21X1
X_2109_ _2109_/A _2181_/B _2110_/A vdd gnd NOR2X1
XFILL_1__2225_ vdd gnd FILL
X_2460_ _4179_/Q _4188_/Q _2461_/A vdd gnd NAND2X1
XFILL_0__2803_ vdd gnd FILL
X_2391_ _3709_/B _3475_/A _2463_/A _2392_/C vdd gnd OAI21X1
XFILL_0__3783_ vdd gnd FILL
X_4130_ _4130_/D _4146_/CLK _4130_/Q vdd gnd DFFPOSX1
X_4061_ _4061_/D _4196_/CLK _4061_/Q vdd gnd DFFPOSX1
XFILL_0__2596_ vdd gnd FILL
X_3012_ _3019_/A _3024_/A _3012_/C _3013_/C vdd gnd OAI21X1
XFILL_0__2665_ vdd gnd FILL
X_3845_ _3845_/D _4147_/CLK _3845_/Q vdd gnd DFFPOSX1
X_3914_ _3914_/D _4032_/CLK _3914_/Q vdd gnd DFFPOSX1
X_3776_ _3803_/Y _3776_/Y vdd gnd INVX1
XFILL_0__3217_ vdd gnd FILL
X_2589_ _2589_/A _2592_/B _2589_/C _2590_/A vdd gnd OAI21X1
X_2727_ _4019_/Q _2730_/A vdd gnd INVX1
XFILL_0__3079_ vdd gnd FILL
X_2658_ _3738_/A _3738_/B _3350_/B _3369_/B vdd gnd MUX2X1
XFILL132450x10950 vdd gnd FILL
XFILL_0__2381_ vdd gnd FILL
XBUFX2_insert174 _2634_/Y _3035_/B vdd gnd BUFX2
XFILL_0__3002_ vdd gnd FILL
XBUFX2_insert185 _3629_/Y _3662_/D vdd gnd BUFX2
X_3630_ _3632_/C _3683_/B _3683_/A _3683_/D _3978_/D vdd gnd OAI22X1
X_1960_ _4048_/Q _1975_/B _1960_/Y vdd gnd NOR2X1
X_2512_ _2512_/A _2685_/S _2513_/C vdd gnd NAND2X1
X_3492_ _3625_/A _3729_/B _3497_/C vdd gnd NAND2X1
X_3561_ _3609_/A _4018_/Q _3561_/C _3563_/B vdd gnd OAI21X1
X_2443_ _4038_/Q _4061_/Q _2444_/B vdd gnd NAND2X1
X_4044_ _4044_/D _4052_/CLK _4044_/Q vdd gnd DFFPOSX1
X_2374_ _3200_/A _2374_/B _3326_/A _2376_/B vdd gnd OAI21X1
XFILL_0__3697_ vdd gnd FILL
X_4113_ _4113_/D _4157_/CLK _4113_/Q vdd gnd DFFPOSX1
XFILL_0__3766_ vdd gnd FILL
XFILL_0__2579_ vdd gnd FILL
X_3759_ _3930_/Q _3760_/A vdd gnd INVX1
X_3828_ _4201_/R vdd _3828_/D _4182_/CLK _3828_/Q vdd gnd DFFSR
XFILL_1__2757_ vdd gnd FILL
XFILL_1_BUFX2_insert105 vdd gnd FILL
XFILL_0__1950_ vdd gnd FILL
X_2090_ _2180_/A _4012_/Q _2091_/A vdd gnd NAND2X1
XFILL_0__3620_ vdd gnd FILL
XFILL_0__2502_ vdd gnd FILL
X_2992_ _2992_/A _2992_/B _2992_/C _2993_/A vdd gnd OAI21X1
XFILL_0__2364_ vdd gnd FILL
XFILL_0__3482_ vdd gnd FILL
XFILL_0__2295_ vdd gnd FILL
X_1943_ _1943_/A _3771_/Y _4163_/D vdd gnd AND2X2
X_3613_ _3617_/A _3988_/Q _3613_/C _3614_/A vdd gnd OAI21X1
X_2426_ _3464_/B _3624_/A _3196_/A _2427_/C vdd gnd OAI21X1
X_3475_ _3475_/A _3475_/B _3475_/C _4053_/D vdd gnd OAI21X1
X_3544_ _3605_/A _3739_/B _3545_/C vdd gnd NAND2X1
XFILL_1__3660_ vdd gnd FILL
XFILL_1__2542_ vdd gnd FILL
X_2357_ _2469_/B _2466_/B vdd gnd INVX1
X_2288_ _3487_/B _2288_/B _2289_/C vdd gnd NAND2X1
X_4027_ _4027_/D _4027_/CLK _4027_/Q vdd gnd DFFPOSX1
XFILL132750x36150 vdd gnd FILL
XFILL_0__2982_ vdd gnd FILL
X_3260_ _4170_/Q _3272_/B _3391_/S _3261_/D vdd gnd OAI21X1
X_3191_ _3382_/B _3794_/A _3267_/C vdd gnd OR2X2
XFILL_0__3603_ vdd gnd FILL
XFILL_0__3534_ vdd gnd FILL
X_2142_ _4122_/Q _3738_/B vdd gnd INVX1
X_2073_ _2073_/A _2163_/B _2074_/A vdd gnd NOR2X1
X_2211_ _2653_/A _2211_/B _2211_/C _2212_/A vdd gnd OAI21X1
X_2975_ _3908_/Q _2992_/A _2976_/C vdd gnd NAND2X1
XFILL_0__2416_ vdd gnd FILL
XFILL_0__3396_ vdd gnd FILL
X_3527_ _3626_/B _3527_/B _3527_/C _4038_/D vdd gnd OAI21X1
X_1926_ _4169_/Q _1926_/B _1928_/B vdd gnd NOR2X1
X_3389_ _3976_/Q _3746_/A vdd gnd INVX1
X_2409_ _3462_/C _3854_/Q _2410_/B vdd gnd OR2X2
X_3458_ _3462_/B _3464_/A vdd gnd INVX1
XFILL_1__3008_ vdd gnd FILL
XFILL_0__3250_ vdd gnd FILL
XFILL_0__2201_ vdd gnd FILL
XFILL_0__2132_ vdd gnd FILL
X_2760_ _2760_/A _4016_/D vdd gnd INVX1
X_2691_ _4011_/Q _2771_/A vdd gnd INVX1
XCLKBUF1_insert133 CLKBUF1_insert187/Y _4050_/CLK vdd gnd CLKBUF1
XCLKBUF1_insert166 CLKBUF1_insert187/Y _4019_/CLK vdd gnd CLKBUF1
XFILL_0__2896_ vdd gnd FILL
XCLKBUF1_insert144 CLKBUF1_insert187/Y _4054_/CLK vdd gnd CLKBUF1
XCLKBUF1_insert155 CLKBUF1_insert187/Y _4139_/CLK vdd gnd CLKBUF1
X_3312_ _3385_/B _3312_/B _3312_/C _4149_/D vdd gnd AOI21X1
X_3243_ _3727_/A _3727_/B _3333_/A _3793_/B vdd gnd MUX2X1
XFILL_0__1916_ vdd gnd FILL
XCLKBUF1_insert188 _3881_/Q CLKBUF1_insert188/Y vdd gnd CLKBUF1
XFILL_1__3290_ vdd gnd FILL
X_3174_ _3174_/A _3693_/B _3175_/B vdd gnd NAND2X1
XFILL_0__3517_ vdd gnd FILL
X_2125_ _3740_/B _2152_/B _2128_/B vdd gnd NOR2X1
X_2056_ _2056_/A _2056_/B _2645_/A _2058_/C vdd gnd OAI21X1
X_2958_ _3914_/Q _3912_/Q _2986_/S _2960_/B vdd gnd MUX2X1
XFILL_1__2172_ vdd gnd FILL
X_2889_ _3025_/S _2895_/B _2889_/C _2891_/B vdd gnd OAI21X1
XFILL_1__1956_ vdd gnd FILL
XFILL_1__3488_ vdd gnd FILL
XFILL_0__2681_ vdd gnd FILL
X_3930_ vdd _3947_/S _3930_/D _4121_/D _3930_/Q vdd gnd DFFSR
X_2743_ _3841_/Q _2743_/B _2751_/C vdd gnd NAND2X1
X_2812_ _2827_/B _2812_/B _2812_/C _2813_/A vdd gnd OAI21X1
X_3861_ _3861_/D _4039_/CLK _3861_/Q vdd gnd DFFPOSX1
X_3792_ _3792_/A _3793_/C vdd gnd INVX1
XFILL_0__3164_ vdd gnd FILL
XFILL_0__3233_ vdd gnd FILL
XFILL_0__2115_ vdd gnd FILL
X_2674_ _2764_/A _2764_/B _2675_/B vdd gnd NAND2X1
XFILL_0__2046_ vdd gnd FILL
XFILL_0__2879_ vdd gnd FILL
X_3157_ _3157_/A _3157_/B _3157_/C _3818_/D vdd gnd AOI21X1
X_3226_ _4183_/Q _3239_/B _3228_/A vdd gnd NAND2X1
XFILL_1__3273_ vdd gnd FILL
X_3088_ _4186_/Q _3741_/A vdd gnd INVX1
X_2108_ _2180_/A _4021_/Q _2109_/A vdd gnd NAND2X1
X_2039_ _4075_/Q _3903_/Q _2228_/S _2040_/B vdd gnd MUX2X1
XFILL_0__2733_ vdd gnd FILL
X_3011_ _3888_/Q _3019_/A _3012_/C vdd gnd NAND2X1
X_4060_ _4060_/D _4101_/CLK _4060_/Q vdd gnd DFFPOSX1
X_2390_ _3478_/C _2397_/B _2390_/C _2400_/C _2390_/Y vdd gnd AOI22X1
X_3913_ _3921_/Y _3917_/Y _3913_/Y vdd gnd AND2X2
X_2726_ _2726_/A _2726_/B _2726_/C _2726_/D _2737_/A vdd gnd AOI22X1
X_3844_ _3947_/S vdd _3844_/D _4201_/CLK _3844_/Q vdd gnd DFFSR
XFILL_0__3147_ vdd gnd FILL
X_3775_ _3804_/Y _3776_/Y _3775_/Y vdd gnd NOR2X1
X_2588_ _2608_/A _2608_/B _4072_/Q _2589_/C vdd gnd OAI21X1
XFILL_1__2911_ vdd gnd FILL
X_2657_ _4201_/Q _3738_/A vdd gnd INVX1
XFILL_0__2029_ vdd gnd FILL
X_4189_ _4189_/D _4189_/CLK _4189_/Q vdd gnd DFFPOSX1
X_3209_ _3939_/Q _3756_/A vdd gnd INVX1
XFILL_1__3325_ vdd gnd FILL
XFILL_1__2207_ vdd gnd FILL
XBUFX2_insert175 _2634_/Y _3053_/A vdd gnd BUFX2
X_3560_ _3609_/A _3743_/B _3561_/C vdd gnd NAND2X1
XBUFX2_insert120 _1966_/Y _2652_/S vdd gnd BUFX2
X_2511_ _3874_/Q _2516_/B _2513_/B vdd gnd NAND2X1
X_2373_ _4141_/Q _3326_/A vdd gnd INVX1
X_3491_ _3496_/B _3522_/B _3491_/C _3491_/D _4049_/D vdd gnd OAI22X1
X_2442_ _3984_/Q _3709_/B _3704_/B _2444_/C vdd gnd NAND3X1
XFILL_0__2716_ vdd gnd FILL
XFILL_0__2647_ vdd gnd FILL
X_4043_ _4043_/D _4049_/CLK _4043_/Q vdd gnd DFFPOSX1
X_4112_ _4112_/D _4114_/CLK _4112_/Q vdd gnd DFFPOSX1
XFILL_1__3110_ vdd gnd FILL
X_2709_ _3009_/B _3022_/B _2747_/C vdd gnd NAND2X1
X_3827_ _3827_/D _4052_/CLK _3827_/Q vdd gnd DFFPOSX1
X_3689_ _3689_/A _3689_/B _3691_/C _3962_/D vdd gnd AOI21X1
X_3758_ _3758_/A _3758_/B _3760_/S _3935_/D vdd gnd MUX2X1
XFILL_1__2687_ vdd gnd FILL
XFILL_1__3308_ vdd gnd FILL
XFILL131850x100950 vdd gnd FILL
XFILL_0__3481_ vdd gnd FILL
XFILL_0__3550_ vdd gnd FILL
X_2991_ _3900_/Q _2992_/A _2992_/C vdd gnd NAND2X1
XFILL_0__2363_ vdd gnd FILL
XFILL_0__2432_ vdd gnd FILL
XFILL132750x3750 vdd gnd FILL
X_1942_ _1958_/C _3721_/B _3722_/A _1943_/A vdd gnd OAI21X1
X_3543_ _3607_/A _3543_/B _3543_/C _4027_/D vdd gnd AOI21X1
X_3612_ _3617_/A _3758_/B _3613_/C vdd gnd NAND2X1
X_2356_ _2356_/A _2681_/A _2469_/B vdd gnd NAND2X1
X_2425_ _3624_/A _3464_/B _3172_/C vdd gnd OR2X2
XFILL_1__3590_ vdd gnd FILL
X_3474_ _4053_/Q _3475_/A _3475_/C vdd gnd NAND2X1
X_4026_ _4026_/D _4050_/CLK _4026_/Q vdd gnd DFFPOSX1
XFILL_0__3748_ vdd gnd FILL
X_2287_ _3237_/A _3897_/A _3184_/A _2288_/B vdd gnd OAI21X1
XFILL_1__3926_ vdd gnd FILL
XFILL_1__3788_ vdd gnd FILL
X_3190_ _4134_/Q _3286_/A _3190_/C _3794_/A vdd gnd OAI21X1
XFILL_0__1932_ vdd gnd FILL
X_2210_ _4117_/Q _3867_/Q _3221_/D _2211_/B vdd gnd MUX2X1
XFILL_0__3464_ vdd gnd FILL
X_2141_ _2186_/A _2141_/B _4122_/D vdd gnd NOR2X1
X_2072_ _2171_/A _4008_/Q _2073_/A vdd gnd NAND2X1
X_2974_ _3906_/Q _3904_/Q _2986_/S _2976_/B vdd gnd MUX2X1
XFILL_0__2346_ vdd gnd FILL
XFILL_0__2277_ vdd gnd FILL
X_1925_ _3771_/A _1925_/B _4169_/D vdd gnd NOR2X1
X_3526_ _3526_/A _4111_/Q _3526_/S _3527_/B vdd gnd MUX2X1
XFILL_1__2524_ vdd gnd FILL
X_2339_ _2530_/A _2530_/B _2556_/B vdd gnd NOR2X1
X_3388_ _3388_/A _3388_/B _3388_/C _4123_/D vdd gnd OAI21X1
X_3457_ _4189_/Q _3457_/B _4179_/Q _3462_/B vdd gnd OAI21X1
X_2408_ _3854_/Q _3462_/C _3170_/B vdd gnd NAND2X1
XFILL_1__3642_ vdd gnd FILL
X_4009_ _4009_/D _4201_/CLK _4009_/Q vdd gnd DFFPOSX1
XFILL_1_CLKBUF1_insert135 vdd gnd FILL
XFILL_1__3909_ vdd gnd FILL
XFILL_1_CLKBUF1_insert157 vdd gnd FILL
XFILL_0__3180_ vdd gnd FILL
XFILL_0__2200_ vdd gnd FILL
X_3311_ _4149_/Q _3385_/B _3312_/C vdd gnd NOR2X1
X_2690_ _4007_/Q _2778_/C vdd gnd INVX1
XFILL_0__2062_ vdd gnd FILL
XCLKBUF1_insert145 CLKBUF1_insert187/Y _4147_/CLK vdd gnd CLKBUF1
XCLKBUF1_insert189 _3881_/Q CLKBUF1_insert189/Y vdd gnd CLKBUF1
XFILL_0__2964_ vdd gnd FILL
XCLKBUF1_insert156 CLKBUF1_insert190/Y _4197_/CLK vdd gnd CLKBUF1
XCLKBUF1_insert167 CLKBUF1_insert191/Y _4192_/CLK vdd gnd CLKBUF1
X_3242_ _3842_/Q _3727_/A vdd gnd INVX1
X_3173_ _3693_/B _3174_/A _3175_/A vdd gnd OR2X2
XCLKBUF1_insert134 CLKBUF1_insert190/Y _4121_/D vdd gnd CLKBUF1
X_2124_ _4126_/Q _3740_/B vdd gnd INVX1
XFILL_0__3447_ vdd gnd FILL
X_2055_ _2055_/A _2172_/B _2056_/A vdd gnd NOR2X1
X_2888_ _2895_/A _2900_/A _2888_/C _2889_/C vdd gnd OAI21X1
XFILL_0__3378_ vdd gnd FILL
X_2957_ _2957_/A _4197_/R _3918_/D vdd gnd AND2X2
X_3509_ _3509_/A _3509_/B _3525_/B _3510_/B vdd gnd OAI21X1
XFILL_1__3625_ vdd gnd FILL
XFILL_0__2680_ vdd gnd FILL
XFILL_0__3301_ vdd gnd FILL
X_2742_ _2742_/A _2742_/B _3038_/C _4026_/D vdd gnd AOI21X1
X_2811_ _3991_/Q _2827_/B _2812_/C vdd gnd NAND2X1
X_3860_ _3976_/R _3860_/Y vdd gnd INVX8
XFILL_0__3094_ vdd gnd FILL
X_3791_ _3791_/A _3801_/A vdd gnd INVX1
X_2673_ _2765_/B _2675_/A vdd gnd INVX1
XFILL_0__2947_ vdd gnd FILL
XFILL_0__2878_ vdd gnd FILL
X_3087_ _3847_/Q _3344_/C _3091_/B vdd gnd NAND2X1
X_3156_ _3157_/A _3157_/B _4180_/R _3157_/C vdd gnd OAI21X1
X_2107_ _3742_/B _2188_/B _2110_/B vdd gnd NOR2X1
X_3225_ _4097_/Q _3227_/B _3225_/C _3239_/B vdd gnd OAI21X1
XFILL_1__2154_ vdd gnd FILL
X_2038_ _2038_/A _2038_/B _2182_/C _2040_/C vdd gnd OAI21X1
X_3989_ _3989_/D _3997_/CLK _3989_/Q vdd gnd DFFPOSX1
XFILL_1__1938_ vdd gnd FILL
XFILL131850x36150 vdd gnd FILL
XFILL_0__2801_ vdd gnd FILL
X_3010_ _3886_/Q _3024_/A vdd gnd INVX1
XFILL_0__2663_ vdd gnd FILL
XFILL_0__3781_ vdd gnd FILL
XFILL_0__2594_ vdd gnd FILL
X_3843_ _3843_/D _4147_/CLK _3843_/Q vdd gnd DFFPOSX1
X_3912_ _3912_/D _4032_/CLK _3912_/Q vdd gnd DFFPOSX1
XFILL_0__3215_ vdd gnd FILL
X_2725_ _2725_/A _2725_/B _2726_/D vdd gnd AND2X2
X_2656_ _4044_/Q _3323_/C _2660_/B vdd gnd NAND2X1
XFILL_0__3077_ vdd gnd FILL
X_3774_ _3775_/Y _3805_/Y _3774_/Y vdd gnd AND2X2
XFILL_0__2028_ vdd gnd FILL
X_2587_ _2587_/A _2758_/A _4074_/D vdd gnd AND2X2
XFILL_1__2841_ vdd gnd FILL
XFILL132750x64950 vdd gnd FILL
X_3208_ _3277_/A _3212_/C vdd gnd INVX1
X_4188_ _4188_/D _4192_/CLK _4188_/Q vdd gnd DFFPOSX1
X_3139_ _3734_/A _3734_/B _3235_/B _3140_/A vdd gnd MUX2X1
XFILL_1__3255_ vdd gnd FILL
XFILL_1__2137_ vdd gnd FILL
XBUFX2_insert110 _1960_/Y _2653_/A vdd gnd BUFX2
X_2510_ _4062_/Q _2602_/A _2515_/A vdd gnd NOR2X1
XFILL_0__3000_ vdd gnd FILL
XBUFX2_insert176 _3726_/Y _3760_/S vdd gnd BUFX2
XBUFX2_insert121 _1966_/Y _2120_/S vdd gnd BUFX2
X_3490_ _3526_/S _4101_/Q _3522_/B _3491_/D vdd gnd OAI21X1
XFILL132450x108150 vdd gnd FILL
X_2372_ _2403_/C _2392_/A vdd gnd INVX1
X_4111_ _4111_/D _4146_/CLK _4111_/Q vdd gnd DFFPOSX1
XFILL_0__3764_ vdd gnd FILL
X_2441_ _3924_/Q _3704_/B vdd gnd INVX1
XFILL_0__2715_ vdd gnd FILL
XFILL_0__2577_ vdd gnd FILL
X_4042_ _4042_/D _4135_/CLK _4042_/Q vdd gnd DFFPOSX1
XFILL_0__3695_ vdd gnd FILL
X_3826_ _4197_/R vdd _3826_/D _4197_/CLK _3826_/Q vdd gnd DFFSR
XFILL_0__3129_ vdd gnd FILL
X_3757_ _3935_/Q _3758_/A vdd gnd INVX1
X_2708_ _2708_/A _4197_/R _4030_/D vdd gnd AND2X2
X_3688_ _3688_/A _3688_/B _3688_/C _3688_/D _3931_/D vdd gnd OAI22X1
X_2639_ _4121_/Q _3806_/Y _4048_/Q _3222_/A vdd gnd OAI21X1
XFILL_1_BUFX2_insert118 vdd gnd FILL
XFILL_0__2500_ vdd gnd FILL
X_2990_ _3898_/Q _3896_/Q _2994_/S _2992_/B vdd gnd MUX2X1
XFILL_0__2293_ vdd gnd FILL
X_1941_ _3696_/B _1941_/B _3722_/A vdd gnd NAND2X1
X_3542_ _4027_/Q _3607_/A _3543_/C vdd gnd NOR2X1
X_3611_ _3611_/A _3611_/B _3611_/C _3988_/D vdd gnd AOI21X1
X_3473_ _3479_/B _3473_/B _3473_/C _3475_/B vdd gnd AOI21X1
X_2355_ _2764_/C _2677_/B _2355_/C _2356_/A vdd gnd OAI21X1
X_2424_ _4191_/Q _2424_/B _2424_/C _3624_/A vdd gnd OAI21X1
XFILL_0__3816_ vdd gnd FILL
X_2286_ _2378_/B _3466_/C _3184_/A vdd gnd NAND2X1
XFILL_1__2471_ vdd gnd FILL
X_4025_ _4025_/D _4027_/CLK _4025_/Q vdd gnd DFFPOSX1
XFILL_0__3678_ vdd gnd FILL
X_3809_ _3809_/A _3809_/B _3864_/Q _3810_/A vdd gnd OAI21X1
XFILL132450x86550 vdd gnd FILL
XFILL_1__2669_ vdd gnd FILL
XFILL_1_BUFX2_insert91 vdd gnd FILL
XFILL_0__2980_ vdd gnd FILL
XFILL_0__3601_ vdd gnd FILL
X_2140_ _2140_/A _4122_/Q _2158_/S _2141_/B vdd gnd MUX2X1
XFILL_0__2414_ vdd gnd FILL
XFILL_0__3532_ vdd gnd FILL
X_2071_ _3746_/B _2179_/B _2074_/B vdd gnd NOR2X1
XFILL_0__3394_ vdd gnd FILL
X_1924_ _4169_/Q _1926_/B _1924_/C _1925_/B vdd gnd AOI21X1
X_2973_ _2973_/A _2997_/B _3910_/D vdd gnd AND2X2
X_3525_ _3525_/A _3525_/B _3525_/C _3526_/A vdd gnd OAI21X1
X_3456_ _3456_/A _3466_/C _3468_/A vdd gnd NOR2X1
X_2338_ _4020_/Q _2530_/B vdd gnd INVX1
X_3387_ _4123_/Q _3388_/A _3388_/C vdd gnd NAND2X1
X_2407_ _2428_/A _3022_/B _3462_/C vdd gnd NOR2X1
X_2269_ _4178_/Q _2378_/B _2270_/B vdd gnd NAND2X1
XFILL_1__3572_ vdd gnd FILL
XFILL132450x18150 vdd gnd FILL
X_4008_ _4008_/D _4036_/CLK _4008_/Q vdd gnd DFFPOSX1
XFILL132450x61350 vdd gnd FILL
XFILL_1__2454_ vdd gnd FILL
XFILL_0__2130_ vdd gnd FILL
X_3310_ _4151_/Q _3310_/B _3310_/C _3312_/B vdd gnd OAI21X1
XFILL_0__2894_ vdd gnd FILL
XFILL_0__1914_ vdd gnd FILL
XCLKBUF1_insert146 CLKBUF1_insert187/Y _4191_/CLK vdd gnd CLKBUF1
XCLKBUF1_insert168 CLKBUF1_insert191/Y _4189_/CLK vdd gnd CLKBUF1
X_3172_ _3172_/A _3172_/B _3172_/C _3174_/A vdd gnd NAND3X1
X_3241_ _4174_/Q _3472_/B vdd gnd INVX1
X_2123_ _2186_/A _2123_/B _4126_/D vdd gnd NOR2X1
XCLKBUF1_insert135 CLKBUF1_insert188/Y _4034_/CLK vdd gnd CLKBUF1
XCLKBUF1_insert157 CLKBUF1_insert188/Y _4049_/CLK vdd gnd CLKBUF1
XFILL_0__3515_ vdd gnd FILL
XFILL_0__2328_ vdd gnd FILL
XFILL_0__3446_ vdd gnd FILL
X_2054_ _2171_/A _4004_/Q _2055_/A vdd gnd NAND2X1
X_2887_ _3950_/Q _2895_/A _2888_/C vdd gnd NAND2X1
X_2956_ _2960_/A _2956_/B _2956_/C _2957_/A vdd gnd OAI21X1
X_3508_ _3519_/A _3508_/B _3509_/B vdd gnd NOR2X1
X_3439_ _4071_/Q _3442_/B vdd gnd INVX1
XFILL_1__2506_ vdd gnd FILL
XFILL_1__2299_ vdd gnd FILL
XFILL_0__3231_ vdd gnd FILL
X_2741_ _4028_/Q _3025_/S _2741_/C _2741_/D _2742_/B vdd gnd AOI22X1
X_2810_ _3989_/Q _3987_/Q _2895_/A _2812_/B vdd gnd MUX2X1
X_3790_ _3790_/A _3802_/B _3802_/D vdd gnd NAND2X1
X_2672_ _2764_/A _2764_/B _2765_/B vdd gnd NOR2X1
XFILL_0__3162_ vdd gnd FILL
XFILL_0__2113_ vdd gnd FILL
XFILL_0__2044_ vdd gnd FILL
X_3224_ _3767_/Y _3224_/B _3225_/C vdd gnd NAND2X1
.ends
